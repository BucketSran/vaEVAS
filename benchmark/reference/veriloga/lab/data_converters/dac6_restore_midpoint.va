// VerilogA for z_2025_PipelindSAR, L1_DAC_restore_6bit, veriloga

`include "constants.vams"
`include "disciplines.vams"

`default_transition 30p

module L1_DAC_restore_6bit(input D1, D2, D3, D4, D5, D6, CLK, output VOUT);

electrical D1, D2, D3, D4, D5, D6, CLK, VOUT;

parameter real vdd = 1.8;
parameter real vpp = 3.6;
parameter real vth = 0.9;
parameter real lsb = 3.6/64;

real vout;

analog begin
	@(cross(V(CLK)-vth, +1)) begin
		vout = 0;
		vout = vout + (V(D1)>vth)*32 + (V(D2)>vth)*16 + (V(D3)>vth)*8 + (V(D4)>vth)*4 + (V(D5)>vth)*2 + (V(D6)>vth)*1;
		vout = (vout + 0.5) * lsb - 1.8;
	end

	V(VOUT) <+ transition(vout);

end

endmodule
