// VerilogA for 2023_TI_SAR, V_ENCODER, veriloga

`include "constants.vams"
`include "disciplines.vams"

module V_DECODER_7B5(D, AOUT7B, AOUT7B5, AOUT8B);
input [8:0]D;
output AOUT7B, AOUT7B5, AOUT8B;
electrical [8:0]D;
electrical AOUT7B, AOUT7B5, AOUT8B;

parameter real vth = 0.5 from [0:inf);
real din[8:0];
real d_lsb;
real aout7b, aout7b5, aout8b;

genvar i;

analog begin
	for(i = 0; i < 9; i = i + 1) begin
		if (V(D[i]) > vth)
			din[i] = 1;
		else
			din[i] = -1;
	end

	if (V(D[1]) > vth && V(D[0]) > vth)
		d_lsb = 1;
	else if (V(D[1]) < vth && V(D[0]) < vth)
		d_lsb = -1;
	else
		d_lsb = 0;

	aout7b = (din[1] * 1 + din[2] * 2 + din[3] * 4 + din[4] * 8 + din[5] * 8 + din[6] * 16 + din[7] * 32 + din[8] * 64) / 136 / 2;
	aout8b = (din[0] * 0.5 + din[1] * 1 + din[2] * 2 + din[3] * 4 + din[4] * 8 + din[5] * 8 + din[6] * 16 + din[7] * 32 + din[8] * 64) / 136 / 2;
	aout7b5 = (d_lsb * 1 + din[2] * 2 + din[3] * 4 + din[4] * 8 + din[5] * 8 + din[6] * 16 + din[7] * 32 + din[8] * 64) / 136 / 2;

	V(AOUT7B) <+ transition(aout7b, 0, 10f);
	V(AOUT8B) <+ transition(aout8b, 0, 10f);
	V(AOUT7B5) <+ transition(aout7b5, 0, 10f);

end

endmodule
