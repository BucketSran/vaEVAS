// VerilogA for SAR_10bit, DAC_10bit, veriloga

`include "constants.vams"
`include "disciplines.vams"
`include "discipline.h"
`include "constants.h"

module DAC4bit_1 (vd3, vd2, vd1, vd0, vout);
electrical vd3, vd2, vd1, vd0, vout;
parameter real vref  = 20m from [0:inf);
parameter real trise = 0 from [0:inf);
parameter real tfall = 0 from [0:inf);
parameter real tdel  = 0 from [0:inf);
parameter real vtrans  = 0.45;

    real out_scaled; // output scaled as fraction of 256

    analog begin
		out_scaled = 0;
		out_scaled = out_scaled + ((V(vd3) > vtrans) ? 8 : 0);
		out_scaled = out_scaled + ((V(vd2) > vtrans) ? 4 : 0);
		out_scaled = out_scaled + ((V(vd1) > vtrans) ? 2 : 0);
		out_scaled = out_scaled + ((V(vd0) > vtrans) ? 1 : 0);
		V(vout) <+ transition( vref*(2*out_scaled/15-1), tdel, trise, tfall );
    end
endmodule
