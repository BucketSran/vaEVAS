`include "constants.vams"
`include "disciplines.vams"

module IDEAL_ADC(Digital, Vip, Vin, CLK);

	inout Digital, Vip, Vin, CLK;
	electrical Digital, Vip, Vin, CLK;
	parameter real Trise = 0 from [0:inf);
	parameter real Tfall = 0 from [0:inf);
	parameter real Tdel = 0 from [0:inf);
	parameter real Vtrans_clk = 0.5 from (0:inf);
	parameter real Vref = 1.0 from (0:inf);
	parameter integer seed = 1 from (0:inf);
	parameter real m_sigma = 0 from [0:inf);
	parameter integer LVL = 16 from (0:inf);

	real Sample;
   	real CMP_LVL;
   	real LSB;
	real H_LSB;
   	real Vod;
   	integer i;

   	analog begin

      	@ ( initial_step ) begin

			LSB = 2 * Vref / LVL;
			H_LSB = LSB / 2;

		end

      	@ (cross(V(CLK) - Vtrans_clk, +1)) begin

         	Sample = V(Vip) - V(Vin);
			CMP_LVL = -Vref;
	     	Vod = 0;

			for (i = 0 ; i <= (LVL - 2) ; i = i + 1) begin

				CMP_LVL = CMP_LVL + LSB;

				if (Sample > CMP_LVL) begin

		           	Vod = Vod + 1;

		     	end

	         end

      	end

      //
      // assign the outputs
      //

      V(Digital) <+ transition(Vod, Tdel, Trise, Tfall);

	end

endmodule
