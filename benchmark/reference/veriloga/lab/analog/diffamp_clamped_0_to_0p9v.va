`include "discipline.h"
`include "constants.h"

// $Date: 1997/08/28 05:48:52 $
// $Revision: 1.1 $
//
//
// Based on the OVI Verilog-A Language Reference Manual, version 1.0 1996
//
//

//--------------------
// diffamp
//
// -  differential amplifier (aka opamp)
//
// sigin_p,sigin_n:	(val,flow)
// sigout:		(val,flow)
//
// INSTANCE parameters
//    gain          = amplifier differential gain (val)
//    sigin_offset  = input offset (val)
//
// MODEL parameters
//    {none}
//
// 'sig_out' is 'gain' times the adjusted input differential signal.
// The adjusted input differential signal is the differential input
// minus 'sigin_offset'
//

module diffamp(sigin_p, sigin_n, sigout);
input sigin_p, sigin_n;
output sigout;
electrical sigin_p, sigin_n, sigout;
parameter real gain = 1;
parameter real sigin_offset = 0;
parameter real sigout_offset = 0.45;

   analog begin
if ((V(sigin_p, sigin_n) - sigin_offset) * gain + sigout_offset > 0.9)
begin
V(sigout) <+ 0.9;
end
else if(((V(sigin_p, sigin_n) - sigin_offset) * gain + sigout_offset < 0))
begin
V(sigout) <+ 0;
end
else
      V(sigout) <+ (V(sigin_p, sigin_n) - sigin_offset) * gain + sigout_offset;
end

endmodule
