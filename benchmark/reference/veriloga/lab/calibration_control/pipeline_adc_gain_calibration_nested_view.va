// VerilogA for UHS_ADC_SUB, TEST_D2A_PIPE_ADC_GAIN_CAL, veriloga

`include "constants.vams"
`include "disciplines.vams"

module TEST_D2A_PIPE_ADC_GAIN_CAL(DIN2,DOUT1,CLKS,GAINCTRL,DDIFF,DOP,DOM,GCTRLCODE);
input [6:0] DIN2;
input CLKS;
output [3:0] DOUT1;
output [6:0] GAINCTRL;
output DDIFF,DOP,DOM,GCTRLCODE;
electrical [6:0] DIN2;
electrical [3:0] DOUT1;
electrical CLKS;
electrical [6:0] GAINCTRL;
electrical DDIFF,DOP,DOM;
electrical GCTRLCODE;
parameter real Vlo=0, Vhi=0.9;
parameter real Vth = 0.45;
parameter real tt = 100p;
parameter integer gaincodeinit = 90;

integer dout_val[6:0];
integer dac1_val[3:0];
integer dacreg[0:6];
integer dout2,doutp,doutm;
integer gainctrlcode;
integer status;
integer ddifcode;
integer stepcode;
genvar i;
analog begin

	@(initial_step) begin
		 gainctrlcode = gaincodeinit;
         dac1_val[3] = 1;
         dac1_val[2] = 0;
         dac1_val[1] = 0;
         dac1_val[0] = 0;
		dacreg[6] = 64;
		dacreg[5] = 32;
		dacreg[4] = 16;
		dacreg[3] = 8;
		dacreg[2] = 4;
		dacreg[1] = 2;
		dacreg[0] = 1;
		 doutp = 96;
		 doutm = 32;
	     status = 0;
		ddifcode=0;
	end

	@(cross(V(CLKS)-Vth,+1)) begin
	//output digital of last cycle

   // read output code
	for(i = 0;i < 7 ; i=i+1)
		begin
		dout_val[i] = V(DIN2[i])>Vth;
		end
    dout2 = 0;
	for(i = 0;i < 7 ; i=i+1)
		begin
		dout2 = dout2 + dout_val[i]*dacreg[i];
		end
    //decide contrl code
    if(status == 1) begin
		doutp = dout2;
        stepcode = abs(doutp - doutm-64);
		ddifcode = doutp - doutm ;
		if(doutp - doutm >64) begin
			gainctrlcode = gainctrlcode-stepcode;
 			if(gainctrlcode<0)begin gainctrlcode=0;end
        end
        if(doutp - doutm <64)  begin
			gainctrlcode = gainctrlcode+stepcode;
 			if(gainctrlcode>127)begin gainctrlcode=127;end
		end
	end
    if(status == 0) begin
		doutm = dout2;
    end
    //change status and code
    if(status == 0) begin
		status = 1;
        dac1_val[3] = 0;
        dac1_val[2] = 1;
        dac1_val[1] = 1;
        dac1_val[0] = 1;
		end
	else begin
		status = 0;
        dac1_val[3] = 1;
        dac1_val[2] = 0;
        dac1_val[1] = 0;
        dac1_val[0] = 0;
		end

	end

for(i = 0;i < 4 ; i=i+1)
	begin
	 V(DOUT1[i]) <+ transition(dac1_val[i]>0?Vhi:Vlo,0,10p);
	end

for(i = 0;i < 7 ; i=i+1)
	begin
	 V(GAINCTRL[i])<+ transition((gainctrlcode>>i)&1?Vhi:Vlo,0,10p);
	end

	 V(DDIFF)<+ transition(ddifcode/100.0,0,10p);
	 V(DOP)<+ transition(doutp/100.0,0,10p);
	 V(DOM)<+ transition(doutm/100.0,0,10p);
V(GCTRLCODE) <+ transition(gainctrlcode/100.0,0,10p);
end
endmodule
