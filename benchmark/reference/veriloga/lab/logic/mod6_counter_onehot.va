// VerilogA for 2023_Pipeline, V_counter, veriloga

`include "constants.vams"
`include "disciplines.vams"

module V_counter(CLK, DOUT, S);

input CLK;
electrical CLK;

parameter vdd = 0.9;

output [2:0] DOUT;
output [5:0] S;
electrical [2:0] DOUT;
electrical [5:0] S;

integer counter = 0;
genvar i ;

analog begin
	@(cross(V(CLK)-0.5*vdd, -1))
		if(counter < 5)
			counter = counter + 1;
		else
			counter = 0;

	for(i = 0; i < 6; i = i + 1)
		V(S[i]) <+ transition((counter == i) * vdd, 50p);

	for(i = 0; i < 3; i = i + 1)
		V(DOUT[i]) <+ transition(((counter >> i) & 1) * vdd, 50p);
end

endmodule
