`include "discipline.h"
`include "constants.h"

// $Date: 1998/09/23 03:13:33 $
// $Revision: 1.2 $
//
//
// Based on the OVI Verilog-A Language Reference Manual, version 1.0 1996
//
//

//--------------------
// d_ff
//
// -  D-type flip flop
//
// vin_d:		[V,A]
// vclk:		[V,A]
// vout_q,vout_qbar:	[V,A]
//
// INSTANCE parameters
//    vlogic_high = output voltage for high [V]
//    vlogic_low  = output voltage for high [V]
//    vtrans      = voltages above this at input are considered high [V]
//    vtrans_clk  = transition voltage of clock [V]
//    tdel, trise, tfall = {usual} [s]
//
// Triggered on the rising edge
//
(* instrument_module *)
module dff_rst(vin_d, vclk, rst, vout_q, vout_qbar);
input vclk, vin_d, rst;
output vout_q, vout_qbar;
electrical vout_q, vout_qbar, vclk, vin_d, rst;
parameter real vlogic_high = 5;
parameter real vlogic_low = 0;
parameter real vtrans_clk = 2.5;
parameter real vtrans = 2.5;
parameter real tdel = 3u from [0:inf);
parameter real trise = 1u from (0:inf);
parameter real tfall = 1u from (0:inf);

   integer x;
   integer xb;

   analog begin
      @ (cross( V(vclk) - vtrans_clk, +1 ))
	begin
         x = (V(vin_d) > vtrans);
	xb = !(V(vin_d) > vtrans);
      end

      @ (cross( V(rst) - vtrans_clk, +1 ))
	begin
         x = 0;
	xb = 0;
      end

         V(vout_q) <+ transition( vlogic_high*x + vlogic_low*xb,
				   tdel, trise, tfall );
         V(vout_qbar) <+ transition( vlogic_high*xb + vlogic_low*x,
				      tdel, trise, tfall );
   end

endmodule
