`include "discipline.h"
`include "constants.h"

// $Date: 1997/08/28 05:45:23 $
// $Revision: 1.1 $
//
//
// Based on the OVI Verilog-A Language Reference Manual, version 1.0 1996
//
//

//--------------------
// open_ckt_fault
//
// -  open circuit fault
//
// vp,vn:		output terminals [V,A]
//
// INSTANCE parameters
//    twait = time to wait before open fault happens [s]
//
// MODEL parameters
//    {none}
//
// At time='twait', the connection between the two terminals is opened. Before
// this the connection between the terminals is closed.
//

module open_ckt_fault(vp, vn);
inout vp, vn;
electrical vp, vn;
parameter real twait = 0.3m;
   analog begin
      if ($abstime < twait)begin
      	 V(vp,vn) <+ 0.0 ;
      end
      else begin
      	 I(vp,vn) <+ 0.0;
      end
   end
endmodule
