`include "discipline.h"
`include "constants.h"

// $Date: 1997/08/28 05:46:22 $
// $Revision: 1.1 $
//
//
// Based on the OVI Verilog-A Language Reference Manual, version 1.0 1996
//
//

//--------------------
// ccvs_hdl
//
// -  current controlled voltage source
//
// vout_p,vout_n:	controlled voltage terminals  [V,A]
// iin_p,iin_n:		controlling current terminals [V,A]
//
// INSTANCE parameters
//    rm = resistance multiplier (V to I gain) [Ohms]
//
// MODEL parameters
//    {none}
//

module ccvs_hdl(vout_p, vout_n, iin_p, iin_n);
input iin_p, iin_n;
output vout_p, vout_n;
electrical vout_p, vout_n, iin_p, iin_n;
parameter real rm = 0;

   analog
      V(vout_p, vout_n) <+ rm*I(iin_p, iin_n);

endmodule
