`include "discipline.h"
`include "constants.h"

// $Date: 1997/08/28 05:48:53 $
// $Revision: 1.1 $
//
//
// Based on the OVI Verilog-A Language Reference Manual, version 1.0 1996
//
//

//--------------------
// diffdriver
//
// -  differential signal driver
//
// sigin_p,sigin_n:	differential input signals (val,flow)
// sigout_p,sigout_n:	differential output signals (val,flow)
// sigref:		differential outputs are with reference to
// 			this node (val,flow)
//
// INSTANCE parameters
//    gain = diffdriver gain []
//
// MODEL parameters
//    {none}
//
// Amplifies its differential pair of input by an amount 'gain',
// producing a differential pair of output signals. The output differential
// signals appear symmetrically about 'sigref'
//

module diffdriver(sigin_p, sigin_n, sigout_p, sigout_n, sigref);
input sigin_p, sigin_n;
output sigout_p, sigout_n;
inout sigref;
electrical sigin_p, sigin_n, sigout_p, sigout_n, sigref;
parameter real gain=1;

   analog begin
      V(sigout_p, sigref) <+ V(sigin_p, sigin_n)*gain/2;
      V(sigout_n, sigref) <+ -V(sigin_p, sigin_n)*gain/2;
   end
endmodule
