`include "discipline.h"
`include "constants.h"

// $Date: 1997/08/28 05:49:16 $
// $Revision: 1.1 $
//
//
// Based on the OVI Verilog-A Language Reference Manual, version 1.0 1996
//
//

`define PI  	3.14159265358979323846264338327950288419716939937511

//--------------------
// val2flow
//
// -  val to flow converter
//
// sigin_p,sigin_n:	[V,A]
// sigout_p,sigout_n:	[V,A]
//
// INSTANCE parameters
//    gain = val to flow gain []
//
// MODEL parameters
//    {none}
//
// flow(sigout_p,sigout_n) = val(sigin_p,sigin_n)
//

module val2flow(sigin_p,sigin_n,sigout_p,sigout_n);
input sigin_p,sigin_n;
output sigout_p,sigout_n;
electrical sigin_p,sigin_n,sigout_p,sigout_n;
parameter real gain = 1;

   analog
      I(sigout_p,sigout_n) <+ gain * V(sigin_p,sigin_n);

endmodule
