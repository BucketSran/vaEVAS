`include "discipline.h"
`include "constants.h"

// $Date: 1997/08/28 05:49:00 $
// $Revision: 1.1 $
//
//
// Based on the OVI Verilog-A Language Reference Manual, version 1.0 1996
//
//

//--------------------
// integrator
//
// -  integrator
//
// sigin:	(val,flow)
// sigout:	(val,flow)
//
// INSTANCE parameters
//    sigout0 = initial sigout value (val)
//    gain    = []
//
// MODEL parameters
//    {none}
//

module integrator(sigin, sigout);
input sigin;
output sigout;
electrical sigin, sigout;
parameter real sigout0 = 0;
parameter real gain = 1;

   analog
   	V(sigout) <+ gain*idt(V(sigin), 0) + sigout0;

endmodule
