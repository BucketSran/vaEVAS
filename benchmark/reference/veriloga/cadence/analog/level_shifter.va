`include "discipline.h"
`include "constants.h"

// $Date: 1997/08/28 05:49:01 $
// $Revision: 1.1 $
//
//
// Based on the OVI Verilog-A Language Reference Manual, version 1.0 1996
//
//

//--------------------
// level_shifter
//
// -  level shifter
//
// sigin:	(val,flow)
// sigout:	(val,flow)
//
// INSTANCE parameters
//    sigshift = level shift (val)
//
// MODEL parameters
//    {none}
//
// 'sigout' = 'sigin' added to 'sigshift'
//

module level_shifter(sigin, sigout);
input sigin;
output sigout;
electrical sigin, sigout;
parameter real sigshift = 0;

   analog
      V(sigout) <+ V(sigin) + sigshift;

endmodule
