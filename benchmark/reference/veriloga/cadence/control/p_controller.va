`include "discipline.h"
`include "constants.h"

// $Date: 1997/08/28 05:48:00 $
// $Revision: 1.1 $
//
//
// Based on the OVI Verilog-A Language Reference Manual, version 1.0 1996
//
//

//--------------------
// p_controller
//
// -  proportional controller
//
// sigin:	(V,I)
// sigout:	(V,I)
//
// INSTANCE parameters
//    kp = proportional gain []
//
// MODEL parameters
//    {none}
//
// 'sigout' = 'kp'*sigin
//
// NOTE
//    Defining larger values of 'abstol' and 'huge' for the quantities
//    associated with sigin and sigout can help overcome convergence and
//    clipping problems.
//

module p_controller(sigin, sigout);
input sigin;
output sigout;
electrical sigin, sigout;
parameter real kp = 1 from [0:inf);

   analog
      V(sigout) <+ kp * V(sigin);
endmodule
