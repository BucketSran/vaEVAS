`include "discipline.h"
`include "constants.h"

// $Date: 1997/08/28 05:48:02 $
// $Revision: 1.1 $
//
//
// Based on the OVI Verilog-A Language Reference Manual, version 1.0 1996
//
//

//--------------------
// pd_controller
//
// -  proportional and derivative controller
//
// sigin:	(V,I)
// sigout:	(V,I)
//
// INSTANCE parameters
//    kp = proportional gain []
//    kd = differential gain []
//
// MODEL parameters
//    {none}
//
// 'sigout' = 'kp'*sigin + 'kd'* ddt ('sigin')
//
// NOTE
//    Defining larger values of 'abstol' and 'huge' for the quantities
//    associated with sigin and sigout can help overcome convergence and
//    clipping problems.
//

module pd_controller(sigin, sigout);
input sigin;
output sigout;
electrical sigin, sigout;
parameter real kp = 1 from [0:inf);
parameter real kd = 0 from [0:inf);

   analog
      V(sigout) <+ kp * V(sigin) + kd * ddt (V(sigin));

endmodule
