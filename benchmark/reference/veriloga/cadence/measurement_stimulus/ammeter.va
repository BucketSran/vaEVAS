`include "discipline.h"
`include"constants.h"

// $Date: 1997/08/28 05:53:20 $
// $Revision: 1.1 $
//
//
// Based on the OVI Verilog-A Language Reference Manual, version 1.0 1996
//
//

`define PI  	3.14159265358979323846264338327950288419716939937511
`define ABSTOL_TIME 1e-12

//--------------------
// ammeter
//
// -  Current meter
//
// vp,vn:	terminals [V,A]
// vout:	measured current converted to a voltage [V,A]
//
// INSTANCE parameters
//    mtype       = type of current measurement; absolute or rms []
//    bw          = bw of output filter (a first order filter) [Hz]
//    log_to_file = whether to log the results to a file; yes or no []
//    filename    = the name of the file in which the results are logged []
//
// MODEL parameters
//    {none}
//
// Measures the current between two of its nodes. It has two modes rms
// (root-mean-squared) and absolute.
//
// The measurement is passed through a first order filter with bandwidth
// 'bw' before being written to file and appearing at 'vout'. This is
// useful when doing rms measurements. If 'bw' is set to zero no filtering
// is done.
//

`define ABSOLUTE 0
`define RMS 1

module ammeter(vp,vn,vout);
electrical vp, vn, vout;
parameter integer mtype = `ABSOLUTE;
parameter real bw = 10 from [0:inf);
parameter integer log_to_file = 0;

   electrical vinter1,vinter2, vgnd;

   svcvs #(.poles({-2*`PI*bw,0})) output_filter   (vinter2,vgnd,vinter1,vgnd);

   integer out_file;

   real iin_val;
   real vin_filter;
   real vout_val;

   real integ_vin_sqd; // for rms calculation
   real input_expr;

   analog begin
      @ ( initial_step ) begin
         if (log_to_file ) begin
             out_file = $fopen( "%C:r.dat" );
             $fstrobe(out_file,"# Generated by Spectre from module `%M'");
         end
      end

      //
      // to ensure that meter is non-instrusive
      //

      V(vp,vn) <+ 0;

      V(vgnd) <+ 0;
      iin_val = I(vp,vn);

      input_expr=0;
      if ( mtype == `RMS )
	   if ($abstime > `ABSTOL_TIME)
               input_expr = iin_val*iin_val;
      integ_vin_sqd  = idt(input_expr,0);

      if (mtype == `RMS) begin
         if ($abstime > `ABSTOL_TIME) begin	// to avoid div by zero error
            vin_filter = sqrt(integ_vin_sqd/$abstime);
         end else begin
            vin_filter = 0;
         end
      end else begin
         vin_filter =  iin_val;
      end

      V(vinter1) <+ vin_filter;

      if (bw != 0 ) begin
         vout_val = V(vinter2);
      end else begin
         vout_val = vin_filter;
      end

      V(vout) <+ vout_val;

      if (log_to_file) begin
         $fstrobe(out_file, "%-.10g\t%-.10g", $abstime, vout_val);
      end

      @ ( final_step ) begin
         if (log_to_file) $fclose(out_file);
      end
   end
endmodule
