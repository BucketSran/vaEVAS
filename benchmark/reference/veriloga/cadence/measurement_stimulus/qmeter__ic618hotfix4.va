`include "discipline.h"
`include"constants.h"

// $Date: 1997/08/28 05:53:33 $
// $Revision: 1.1 $
//
//
// Based on the OVI Verilog-A Language Reference Manual, version 1.0 1996
//
//

//--------------------
// qmeter
//
// -  Charge meter
//
// vp,vn:	terminals [V,A]
// qout:	measured charge [C,A]
//
// INSTANCE parameters
//    tstart      = start time [s]
//    tend        = end time [s]
//    log_to_file = whether to log the results to a file; yes or no []
//
// MODEL parameters
//    {none}
//
// Measures the charge that has flown between 'vn' and 'vp' between 'tstart'
// and 'tend'.
//

nature Q_Charge
	abstol = 1e-15;
	huge=1;
	units = "C";
	access = QQ;
endnature

discipline charge_current
	potential Q_Charge;
	flow Current;
enddiscipline

(* instrument_module *)
module qmeter(vp,vn,qout);
electrical vp, vn;
charge_current qout;
parameter real tstart = 0 from [0:inf);
parameter real tend = 1M from (0:inf];
parameter integer log_to_file = 0;

   integer out_file;

   real iin_val;
   real input_expr;

   integer measuring;

   real qout_val;

   analog begin
      @ ( initial_step ) begin
         if (tend <= tstart) begin
            $display("Range specification error.  tend = (%E) less than tstart = (%E).", tend, tstart );
		$finish;
         end

         if (log_to_file ) begin
             out_file = $fopen( "%C:r.dat" );
             $fstrobe(out_file,"# Generated by Spectre from module `%M'");
         end
      end

      V(vp,vn) <+ 0;

      iin_val = I(vp,vn);

      @ ( timer(tstart)) begin
         measuring = 1;
      end

     @ ( timer(tend)) begin
         measuring = 0;
      end

      if ( measuring )
          input_expr = iin_val;
      else
          input_expr = 0;

      qout_val = idt(input_expr,0);

      if (log_to_file ) begin
         $fstrobe(out_file, "%-.10g\t%-.10g", $abstime, qout_val);
      end

      QQ(qout) <+ qout_val;

      @ ( final_step ) begin
         if (log_to_file) $fclose(out_file);
      end
   end
endmodule
