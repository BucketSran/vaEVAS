`include "discipline.h"
`include "constants.h"

// $Date: 1998/09/23 03:13:33 $
// $Revision: 1.2 $
//
//
// Based on the OVI Verilog-A Language Reference Manual, version 1.0 1996
//
//

//--------------------
// full_adder
//
// -  full adder
//
// vin1,vin2:	bits to be added [V,A]
// vin_carry:	carry in  [V,A]
// vout_sum:	sum out	  [V,A]
// vout_carry:	carry out [V,A]
//
// INSTANCE parameters
//    vlogic_high = logic high value  [V]
//    vlogic_low  = logic low value [V]
//    vtrans      = threshold for inputs to be high [V]
//    tdel, trise, tfall = {usual} [s]
//

module full_adder(vin1, vin2, vin_carry, vout_sum, vout_carry);
input vin1, vin2, vin_carry;
output vout_sum, vout_carry;
electrical vin1, vin2, vin_carry, vout_sum, vout_carry;
parameter real vlogic_high = 5;
parameter real vlogic_low = 0;
parameter real vtrans = 1.4;
parameter real tdel = 3u from [0:inf);
parameter real trise = 1u from (0:inf);
parameter real tfall = 1u from (0:inf);

   integer a, b, c;
   real vout_sum_val;
   real vout_carry_val;

   analog begin

      @ ( initial_step ) begin
	 if (vlogic_high < vlogic_low) begin
	    $display("Range specification error.  vlogic_high = (%E) less than vlogic_low = (%E).\n", vlogic_high, vlogic_low );
	    $finish;
	 end
	 if (vtrans > vlogic_high || vtrans < vlogic_low) begin
	    $display("Inconsistent $threshold specification w/logic family.\n");
	 end
      end

      a = V(vin1) > vtrans;
      b = V(vin2) > vtrans;
      c = V(vin_carry) > vtrans;

      @ (cross(V(vin1) - vtrans, 1))   a = 1;
      @ (cross(V(vin1) - vtrans, -1))  a = 0;

      @ (cross(V(vin2) - vtrans, 1))   b = 1;
      @ (cross(V(vin2) - vtrans, -1))  b = 0;

      @ (cross(V(vin_carry) - vtrans, 1))  c = 1;
      @ (cross(V(vin_carry) - vtrans, -1)) c = 0;

      vout_sum_val = (c ^ a ^ b) ? vlogic_high : vlogic_low;

      vout_carry_val = ((c && (a || b)) || (a && b))
                           ? vlogic_high : vlogic_low;

      V(vout_sum) <+ transition( vout_sum_val, tdel, trise, tfall);
      V(vout_carry) <+ transition( vout_carry_val, tdel, trise, tfall);
   end
endmodule
