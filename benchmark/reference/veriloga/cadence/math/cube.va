`include "discipline.h"
`include "constants.h"

// $Date: 1997/08/28 05:52:23 $
// $Revision: 1.1 $
//
//
// Based on the OVI Verilog-A Language Reference Manual, version 1.0 1996
//
//

//--------------------
// cube
//
// -  cube
//
// sigin:	(val,flow)
// sigout:	(val,flow)
//
// INSTANCE parameters
//    {none}
//
// MODEL parameters
//    {none}
//
// 'sigout' is the cube of the 'sigin'
//

module cube (sigin, sigout);
input sigin;
output sigout;
electrical sigin, sigout;

   analog
      V(sigout) <+ V(sigin) * V(sigin) * V(sigin);

endmodule
