`include "discipline.h"
`include "constants.h"

// $Date: 1997/08/28 05:52:31 $
// $Revision: 1.1 $
//
//
// Based on the OVI Verilog-A Language Reference Manual, version 1.0 1996
//
//

//--------------------
// natural_log
//
// -  natural log function
//
// sigin:	(val,flow)
// sigout:	(val,flow)
//
// INSTANCE parameters
//    min_sigin = minimum value of 'sigin' (val)
//
// MODEL parameters
//    {none}
//
// 'sigout' is the natural log of 'sigin', providing 'sigin' > 'min_sigin'
// If 'sigin' is between 0 and 'min_sigin' then 'sigout' is the log of
// 'min_sigin'. If 'sigin' is less than 0, an error is reported.
//

module natural_log (sigin, sigout );
input sigin;
output sigout;
electrical sigin, sigout;
parameter real min_sigin = 1.0e-6;

   real sigin_val;

   analog begin

      sigin_val = V(sigin);
      if ( sigin_val < 0.0 ) begin
         $display(" Cannot take logarithm of a negative number.\n");
         $finish;
      end else if ( sigin_val > min_sigin)
	 V(sigout) <+ ln(sigin_val);
      else
	 V(sigout) <+ ln(min_sigin);

   end
endmodule
