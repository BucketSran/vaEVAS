`include "discipline.h"
`include "constants.h"

// $Date: 1997/08/28 05:52:20 $
// $Revision: 1.1 $
//
//
// Based on the OVI Verilog-A Language Reference Manual, version 1.0 1996
//
//

//--------------------
// adder
//
// -  adds two node values
//
// sigin1,sigin2:	(val,flow)
// sigout:		(val,flow)
//
// INSTANCE parameters
//    k1 = gain of sigin1 []
//    k2 = gain of sigin2 []
//
// MODEL parameters
//    {none}
//

module adder(sigin1, sigin2, sigout);
input sigin1, sigin2;
output sigout;
electrical sigin1, sigin2, sigout;
parameter real k1 = 1;
parameter real k2 = 1;

   analog
   	V(sigout) <+ k1*V(sigin1) + k2*V(sigin2);

endmodule
