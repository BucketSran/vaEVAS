`include "discipline.h"
`include "constants.h"

// $Date: 1997/08/28 05:52:18 $
// $Revision: 1.1 $
//
//
// Based on the OVI Verilog-A Language Reference Manual, version 1.0 1996
//
//

//--------------------
// absolute_value
//
// -  absolute value
//
// sigin:	(val,flow)
// sigout:	(val,flow)
//
// INSTANCE parameters
//    {none}
//
// MODEL parameters
//    {none}
//
// 'sigout' is the absolute value of 'sigin'
//

module absolute_value(sigin, sigout);
input sigin;
output sigout;
electrical sigin, sigout;

   analog
      V(sigout) <+ abs(V(sigin));

endmodule
