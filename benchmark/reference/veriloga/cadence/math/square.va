`include "discipline.h"
`include "constants.h"

// $Date: 1997/08/28 05:52:39 $
// $Revision: 1.1 $
//
//
// Based on the OVI Verilog-A Language Reference Manual, version 1.0 1996
//
//

//--------------------
// square
//
// -  square
//
// sigin:	input
// sigout:	output
//
// INSTANCE parameters
//    {none}
//
// MODEL parameters
//    {none}
//
// 'sigout' is the square of the 'sigin'
//

module square (sigin, sigout);
input sigin;
output sigout;
electrical sigin, sigout;

   analog
      V(sigout) <+ V(sigin) * V(sigin);

endmodule
