`include "constants.vams"
`include "disciplines.vams"

module uvlo_brownout_detector(clk, rst, vin, out, metric);
input clk, rst, vin;
output out, metric;
electrical clk, rst, vin, out, metric;
parameter real tr = 100p;
parameter real vth = 0.45;
real pgood, metricv;
analog begin
    @(initial_step) begin
        pgood = 0.0;
        metricv = 0.9;
    end
    @(cross(V(clk) - vth, +1)) begin
        if (V(rst) > vth) begin
            pgood = 0.0;
        end else begin
            if (V(vin) > 0.60) begin
                pgood = 0.9;
            end else begin
                pgood = 0.0;
            end
        end
        metricv = (pgood > 0.45) ? 0.1 : 0.9;
    end
    V(out) <+ transition(pgood, 0, tr, tr);
    V(metric) <+ transition(metricv, 0, tr, tr);
end
endmodule
