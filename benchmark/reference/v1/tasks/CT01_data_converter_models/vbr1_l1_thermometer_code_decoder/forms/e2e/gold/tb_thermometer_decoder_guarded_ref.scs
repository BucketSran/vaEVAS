simulator lang=spectre
global 0

ahdl_include "thermometer_decoder_guarded.va"

Ven (en 0) vsource type=pwl wave=[0 0 20n 0 21n 0.9 120n 0.9]
Vb0 (b0 0) vsource type=pwl wave=[0 0 39.5n 0 40n 0.9 59.5n 0.9 60n 0 79.5n 0 80n 0.9 120n 0.9]
Vb1 (b1 0) vsource type=pwl wave=[0 0 39.5n 0 40n 0 59.5n 0 60n 0.9 79.5n 0.9 80n 0.9 120n 0.9]

XDUT (b0 b1 en th0 th1 th2 th3) thermometer_decoder_guarded

tran tran stop=120n maxstep=500p
save b0 b1 en th0 th1 th2 th3
