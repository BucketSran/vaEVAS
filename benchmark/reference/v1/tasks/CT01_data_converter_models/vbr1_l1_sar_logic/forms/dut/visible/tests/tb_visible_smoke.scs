simulator lang=spectre
global 0

ahdl_include "sar_logic_4b.va"

V_VDD (VDD 0) vsource dc=0.9
V_VSS (VSS 0) vsource dc=0
V_CLKS (CLKS 0) vsource type=pulse val0=0 val1=0.9 period=1n delay=100p rise=20p fall=20p width=450p
V_DCOMP (DCOMP 0) vsource type=pulse val0=0 val1=0.9 period=3n delay=300p rise=50p fall=50p width=1.4n

XDUT (VDD VSS CLKS DCOMP DP_DAC_3 DP_DAC_2 DP_DAC_1 DP_DAC_0 RDY) sar_logic_4b

tran tran stop=5n maxstep=100p
save VDD VSS CLKS DCOMP
