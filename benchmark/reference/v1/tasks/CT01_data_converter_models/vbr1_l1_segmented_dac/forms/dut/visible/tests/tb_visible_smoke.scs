simulator lang=spectre
global 0

ahdl_include "segmented_dac.va"

V_b0 (b0 0) vsource type=pulse val0=0 val1=0.9 period=3n delay=0p rise=50p fall=50p width=1.4n
V_b1 (b1 0) vsource type=pulse val0=0 val1=0.9 period=3n delay=100p rise=50p fall=50p width=1.4n
V_t0 (t0 0) vsource type=pulse val0=0 val1=0.9 period=3n delay=200p rise=50p fall=50p width=1.4n
V_t1 (t1 0) vsource type=pulse val0=0 val1=0.9 period=3n delay=300p rise=50p fall=50p width=1.4n
V_t2 (t2 0) vsource type=pulse val0=0 val1=0.9 period=3n delay=400p rise=50p fall=50p width=1.4n
V_vref (vref 0) vsource dc=0.9
V_vss (vss 0) vsource dc=0

XDUT (b0 b1 t0 t1 t2 vref vss aout) segmented_dac

tran tran stop=5n maxstep=100p
save b0 b1 t0 t1 t2 vref vss
