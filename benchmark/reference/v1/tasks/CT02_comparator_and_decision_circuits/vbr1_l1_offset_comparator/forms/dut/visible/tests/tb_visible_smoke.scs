simulator lang=spectre
global 0

ahdl_include "cmp_offset_ref.va"

V_VDD (VDD 0) vsource dc=0.9
V_VSS (VSS 0) vsource dc=0
V_CLK (CLK 0) vsource type=pulse val0=0 val1=0.9 period=1n delay=100p rise=20p fall=20p width=450p
V_VINP (VINP 0) vsource type=pulse val0=0 val1=0.9 period=3n delay=300p rise=50p fall=50p width=1.4n
V_VINN (VINN 0) vsource type=pulse val0=0 val1=0.9 period=3n delay=400p rise=50p fall=50p width=1.4n

XDUT (VDD VSS CLK VINP VINN OUT_P) cmp_offset_ref

tran tran stop=5n maxstep=100p
save VDD VSS CLK VINP VINN
