simulator lang=spectre
global 0

ahdl_include "debounce_latch.va"

V_sig (sig 0) vsource type=pulse val0=0 val1=0.9 period=3n delay=0p rise=50p fall=50p width=1.4n
V_rst_n (rst_n 0) vsource type=pulse val0=0.9 val1=0 period=20n delay=1n rise=50p fall=50p width=18n

XDUT (sig rst_n out) debounce_latch

tran tran stop=5n maxstep=100p
save sig rst_n
