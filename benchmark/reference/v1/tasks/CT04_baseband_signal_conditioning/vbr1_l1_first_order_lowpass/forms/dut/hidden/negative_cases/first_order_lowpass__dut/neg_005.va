`include "constants.vams"
`include "disciplines.vams"

module first_order_lowpass(vin,vout);
    input vin; output vout; electrical vin,vout; parameter real tr=200p; real y;
    analog begin @(initial_step) y=0.0; @(timer(0,500p)) y = 0.0; V(vout)<+transition(y,0,tr,tr); end
endmodule
