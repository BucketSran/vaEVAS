`include "constants.vams"
`include "disciplines.vams"

module resettable_integrator(vin, rst, vout);
    input vin, rst;
    output vout;
    electrical vin, rst, vout;
    parameter real vth = 0.45;
    parameter real gain = 1.0e9;
    parameter real dt = 1n;
    parameter real vmax = 0.85;
    parameter real tr = 500p;

    // TODO: implement the behavior described in visible/prompt.md.
    // This starter is intentionally incomplete; hidden tests grade behavior.
endmodule
