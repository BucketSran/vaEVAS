`include "constants.vams"
`include "disciplines.vams"

module resettable_integrator(vin, rst, vout);
    input vin, rst; output vout; electrical vin, rst, vout; parameter real vth=0.45; parameter real dt=1n; parameter real tr=500p; real acc;
    analog begin @(initial_step) acc=0.0; @(timer(0,dt)) begin if (V(rst)>vth) acc=0.0; else acc=0.0; end V(vout)<+transition(acc,0,tr,tr); end
endmodule
