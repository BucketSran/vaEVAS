`include "constants.vams"
`include "disciplines.vams"

module bbpd_ref (
    input  electrical data,
    input  electrical clk,
    input  electrical retimed_data,
    output electrical up,
    output electrical down
);

parameter real vdd = 0.9;
parameter real vth = 0.45;
parameter real trf = 10p;
parameter real td  = 0p;

    // TODO: implement the behavior described in visible/prompt.md.
    // This starter is intentionally incomplete; hidden tests grade behavior.
endmodule
