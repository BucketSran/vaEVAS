simulator lang=spectre
global 0

ahdl_include "element_shuffler.va"

V_clk (clk 0) vsource type=pulse val0=0 val1=0.9 period=1n delay=100p rise=20p fall=20p width=450p
V_rst_n (rst_n 0) vsource type=pulse val0=0.9 val1=0 period=20n delay=1n rise=50p fall=50p width=18n

XDUT (clk rst_n out0 out1 out2 out3) element_shuffler

tran tran stop=5n maxstep=100p
save clk rst_n
