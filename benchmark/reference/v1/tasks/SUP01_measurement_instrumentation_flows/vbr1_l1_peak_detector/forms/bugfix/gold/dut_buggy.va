`include "constants.vams"
`include "disciplines.vams"

module peak_detector(vin, rst, vout);
    input vin, rst;
    output vout;
    electrical vin, rst, vout;

    parameter real tr = 500p;
    real peak;

    analog begin
        @(initial_step) peak = 0.0;

        @(timer(0, 500p)) begin
            if (V(vin) > peak)
                peak = V(vin);
        end

        V(vout) <+ transition(peak, 0, tr, tr);
    end
endmodule
