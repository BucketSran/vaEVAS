`include "disciplines.vams"
module limiter_rails (vdd, vss, vin, vmax, vmin, vout);
input vdd, vss, vin, vmax, vmin; output vout; electrical vdd, vss, vin, vmax, vmin, vout;
analog begin
    if (V(vin)>V(vdd)) V(vout)<+V(vdd);
    else if (V(vin)<V(vss)) V(vout)<+V(vss);
    else V(vout)<+V(vin);
end
endmodule
