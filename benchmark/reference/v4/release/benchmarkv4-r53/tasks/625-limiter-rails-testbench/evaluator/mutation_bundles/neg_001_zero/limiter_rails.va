`include "disciplines.vams"

module limiter_rails (vdd, vss, vin, vmax, vmin, vout);

input vdd, vss, vin, vmax, vmin;
output vout;
electrical vdd, vss, vin, vmax, vmin, vout;

analog begin
    V(vout) <+ 0;
end

endmodule
