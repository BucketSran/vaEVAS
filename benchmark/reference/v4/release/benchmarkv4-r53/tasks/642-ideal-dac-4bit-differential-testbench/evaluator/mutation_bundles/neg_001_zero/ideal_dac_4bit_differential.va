`include "disciplines.vams"

module ideal_dac_4bit_differential(clk, digital, vcm, vop, von);
input clk, digital, vcm;
output vop, von;
electrical clk, digital, vcm, vop, von;

analog begin
    V(vop) <+ 0;
end

endmodule
