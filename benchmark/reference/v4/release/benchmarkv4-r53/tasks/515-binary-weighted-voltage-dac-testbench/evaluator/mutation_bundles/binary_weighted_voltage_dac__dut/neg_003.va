`include "constants.vams"
`include "disciplines.vams"

module simple_binary_voltage_dac_4b(code_0, code_1, code_2, code_3, vref, vss, aout);
    input code_0, code_1, code_2, code_3, vref, vss;
    output aout;
    electrical code_0, code_1, code_2, code_3, vref, vss, aout;
    parameter real vth = 0.45;
    parameter real tr = 500p;
    integer code;
    real y;
    analog begin
        code = (V(code_0)>vth?8:0) + (V(code_1)>vth?4:0) + (V(code_2)>vth?2:0) + (V(code_3)>vth?1:0);
        y = V(vss) + (V(vref)-V(vss))*code/15.0;
        V(aout, vss) <+ slew(y - V(vss), 0.9 / (tr), -0.9 / (tr));
    end
endmodule

// vaBench partial-pass negative 3 for binary_weighted_voltage_dac:dut
// Intended to preserve interface/smoke behavior while failing full checks.
// Mutation note: polarity_direction_near_miss. The bit significance is
// reversed, preserving interface shape while failing code-to-voltage mapping.
