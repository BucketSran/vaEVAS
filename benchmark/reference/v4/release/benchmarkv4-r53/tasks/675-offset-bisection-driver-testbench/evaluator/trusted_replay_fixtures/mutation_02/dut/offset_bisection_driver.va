`include "disciplines.vams"

        module offset_bisection_driver(clk, vout, vcm, vinp, vinn);
        input clk, vout, vcm;
        output vinp, vinn;
        electrical clk, vout, vcm, vinp, vinn;

analog begin
    V(vinp) <+ 0;
    V(vinn) <+ 0;
end

endmodule
