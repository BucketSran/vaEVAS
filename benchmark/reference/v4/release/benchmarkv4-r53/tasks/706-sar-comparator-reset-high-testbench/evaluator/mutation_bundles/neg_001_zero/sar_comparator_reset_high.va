`include "disciplines.vams"
module sar_comparator_reset_high(cmpck, vinn, vinp, dcmpn, dcmpp);
input cmpck, vinn, vinp;
output dcmpn, dcmpp;
electrical cmpck, vinn, vinp, dcmpn, dcmpp;
analog begin
    V(dcmpp) <+ 0.0;
    V(dcmpn) <+ 0.0;
end
endmodule
