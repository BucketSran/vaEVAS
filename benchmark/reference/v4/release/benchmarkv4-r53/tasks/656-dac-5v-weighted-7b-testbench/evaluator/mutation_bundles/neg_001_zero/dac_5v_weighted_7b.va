`include "disciplines.vams"

module dac_5v_weighted_7b(clks, din0, din1, din2, din3, din4, din5, din6, vout);
input clks, din0, din1, din2, din3, din4, din5, din6;
output vout;
electrical clks, din0, din1, din2, din3, din4, din5, din6, vout;
//

analog begin
    V(vout) <+ 0;
end

endmodule
