`include "disciplines.vams"
module weighted_decoder_6bit(vd1, vd2, vd3, vd4, vd5, vd6, vout);
input vd1, vd2, vd3, vd4, vd5, vd6;
output vout;
electrical vd1, vd2, vd3, vd4, vd5, vd6, vout;
analog begin
    V(vout) <+ 0.0;
end
endmodule
