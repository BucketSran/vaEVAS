`include "disciplines.vams"
module pfd_active_low_reset(ref, fb, rstb, up, down);
input ref, fb, rstb;
output up, down;
electrical ref, fb, rstb, up, down;
analog begin
    V(up) <+ 0.0;
    V(down) <+ 0.0;
end
endmodule
