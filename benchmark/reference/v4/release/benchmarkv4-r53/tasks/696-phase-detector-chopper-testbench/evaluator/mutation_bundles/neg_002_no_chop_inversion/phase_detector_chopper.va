`include "disciplines.vams"
module phase_detector_chopper(vlocal_osc, vin_rf, vif);
input vlocal_osc, vin_rf;
output vif;
electrical vlocal_osc, vin_rf, vif;
parameter real gain = 1.25;
analog begin
    V(vif) <+ gain * V(vin_rf);
end
endmodule
