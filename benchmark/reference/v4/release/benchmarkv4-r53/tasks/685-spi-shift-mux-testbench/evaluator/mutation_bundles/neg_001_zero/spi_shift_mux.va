`include "disciplines.vams"
        module spi_shift_mux(scki, sdi, rst, out0, out1, out2, out3, out4, out5, out6, out7, sdo, scko);
        input scki, sdi, rst;
        output out0, out1, out2, out3, out4, out5, out6, out7, sdo, scko;
        electrical scki, sdi, rst, out0, out1, out2, out3, out4, out5, out6, out7, sdo, scko;

analog begin
    V(out0) <+ 0;
    V(out1) <+ 0;
    V(out2) <+ 0;
    V(out3) <+ 0;
    V(out4) <+ 0;
    V(out5) <+ 0;
    V(out6) <+ 0;
    V(out7) <+ 0;
    V(sdo) <+ 0;
    V(scko) <+ 0;
end

endmodule
