`include "disciplines.vams"
module sample_hold_5v_clock(vin, vout, vclk);
input vin, vclk;
output vout;
electrical vin, vout, vclk;
analog begin
    V(vout) <+ 0.0;
end
endmodule
