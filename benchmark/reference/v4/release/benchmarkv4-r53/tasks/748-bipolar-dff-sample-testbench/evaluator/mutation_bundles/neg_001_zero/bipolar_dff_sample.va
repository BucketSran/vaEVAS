`include "disciplines.vams"
module bipolar_dff_sample(vin_d, vclk, vout_q, vout_qbar);
input vin_d, vclk;
output vout_q, vout_qbar;
electrical vin_d, vclk, vout_q, vout_qbar;
analog begin
    V(vout_q) <+ 0.0;
    V(vout_qbar) <+ 0.0;
end
endmodule
