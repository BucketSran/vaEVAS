`include "disciplines.vams"

module dual_modulus_divider_16_17(fin, mc, fout);
input fin, mc;
output fout;
electrical fin, mc, fout;

analog begin
    V(fout) <+ 0;
end

endmodule
