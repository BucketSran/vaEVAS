`include "disciplines.vams"

module ideal_clkmux_8channel(clk, in0, in1, in2, in3, in4, in5, in6, in7, out, count_x);
input clk, in0, in1, in2, in3, in4, in5, in6, in7;
output out, count_x;
electrical clk, in0, in1, in2, in3, in4, in5, in6, in7, out, count_x;

analog begin
    V(out) <+ 0;
    V(count_x) <+ 0;
end

endmodule
