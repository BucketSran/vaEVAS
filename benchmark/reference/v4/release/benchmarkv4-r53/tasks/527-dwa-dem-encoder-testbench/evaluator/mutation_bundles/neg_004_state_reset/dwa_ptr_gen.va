`include "constants.vams"
`include "disciplines.vams"

`default_transition 10p
module dwa_ptr_gen (
    input electrical clk_i,
    input electrical rst_ni,
    input electrical [3:0] code_msb_i,
    output electrical [15:0] cell_en_o,
    output electrical [15:0] ptr_o
);
parameter real vdd=0.9; parameter real vth=0.45; parameter integer ptr_init=0;
integer start_idx_q; integer msb_count_q; integer lsb_idx; integer dist; integer j; genvar i;
real cell_en_val[15:0]; real ptr_val[15:0];
analog begin
    @(initial_step) begin start_idx_q=ptr_init; msb_count_q=0; for (j=0; j<16; j=j+1) begin cell_en_val[j]=0.0; ptr_val[j]=0.0; end end
    @(cross(V(clk_i)-vth,+1)) begin
        if (V(rst_ni)<vth) begin start_idx_q=ptr_init; msb_count_q=0; end
        else begin
            msb_count_q=0;
            if (V(code_msb_i[0])>vth) msb_count_q=msb_count_q+1;
            if (V(code_msb_i[1])>vth) msb_count_q=msb_count_q+2;
            if (V(code_msb_i[2])>vth) msb_count_q=msb_count_q+4;
            if (V(code_msb_i[3])>vth) msb_count_q=msb_count_q+8;
            start_idx_q = (start_idx_q + msb_count_q + 1) % 16;
        end
        lsb_idx=(start_idx_q-msb_count_q+16)%16;
        for (j=0; j<16; j=j+1) begin dist=(start_idx_q-j+16)%16; cell_en_val[j] = ((dist < msb_count_q) || (j == lsb_idx)) ? vdd : 0.0; ptr_val[j] = (j == start_idx_q) ? vdd : 0.0; end
        $strobe("[dwa_ptr_gen] t=%.3f ns | ptr=%2d | msb=%2d | lsb=%2d", $abstime*1e9, start_idx_q, msb_count_q, lsb_idx);
    end
    for (i=0; i<16; i=i+1) begin V(cell_en_o[i]) <+ transition(cell_en_val[i]); V(ptr_o[i]) <+ transition(ptr_val[i]); end
end
endmodule
