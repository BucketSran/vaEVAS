simulator lang=spectre
global 0

ahdl_include "../submission/edge_delay_line_deglitch.va"

Vin (vin 0) vsource type=pwl wave=[0 0 5n 0 5.05n 0.9 15n 0.9 15.05n 0 24n 0 24.05n 0.9 24.45n 0.9 24.50n 0 34n 0 34.05n 0.9 47n 0.9 47.05n 0 62n 0]
Vrst (rst 0) vsource type=pwl wave=[0 0.9 1n 0.9 1.1n 0 62n 0]
Ven (enable 0) vsource type=pwl wave=[0 0 2n 0 2.1n 0.9 52n 0.9 52.1n 0 56n 0 56.1n 0.9 62n 0.9]
XDUT (vin rst enable vout edge_valid rejected) edge_delay_line_deglitch

tran tran stop=62n maxstep=50p
save vin rst enable vout edge_valid rejected
