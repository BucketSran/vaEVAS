`include "constants.vams"
`include "disciplines.vams"

module ratio_monitor(decision_tick, rst, enable, div_sel, avg_ratio_metric, valid);
    input decision_tick, rst, enable, div_sel;
    output avg_ratio_metric, valid;
    electrical decision_tick, rst, enable, div_sel, avg_ratio_metric, valid;

    parameter real vdd = 0.9;
    parameter real vss = 0.0;
    parameter real vth = 0.45;
    parameter integer n_int = 8 from [1:inf);
    parameter integer window_len = 16 from [1:inf);
    parameter real tr = 100p from (0:inf);

    integer sample_count;
    integer larger_count;
    real avg_value;
    real valid_value;

    analog begin
        @(initial_step) begin
            sample_count = 0;
            larger_count = 0;
            avg_value = vss;
            valid_value = vss;
        end

        @(cross(V(decision_tick) - vth, +1)) begin
            if ((V(rst) > vth) || (V(enable) <= vth)) begin
                sample_count = 0;
                larger_count = 0;
                avg_value = vss;
                valid_value = vss;
            end else begin
                sample_count = sample_count + 1;
                if (V(div_sel) > vth)
                    larger_count = larger_count + 1;
                valid_value = vss;
                if (sample_count >= window_len) begin
                    avg_value = n_int + (1.0 * larger_count) / window_len;
                    sample_count = 0;
                    larger_count = 0;
                    valid_value = vdd;
                end
            end
        end

        @(cross(V(rst) - vth, +1) or cross(V(enable) - vth, -1)) begin
            sample_count = 0;
            larger_count = 0;
            avg_value = vss;
            valid_value = vdd;
        end

        V(avg_ratio_metric) <+ transition(avg_value, 0, tr, tr);
        V(valid) <+ transition(valid_value, 0, tr, tr);
    end
endmodule
