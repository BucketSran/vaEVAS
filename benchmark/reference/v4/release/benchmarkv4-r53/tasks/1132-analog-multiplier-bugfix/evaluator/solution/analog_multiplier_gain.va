`include "disciplines.vams"

module analog_multiplier_gain(sigin1, sigin2, sigout);
input sigin1, sigin2;
output sigout;
electrical sigin1, sigin2, sigout;
parameter real gain = 1;

analog begin
    V(sigout) <+ gain * V(sigin1) * V(sigin2);
end

endmodule
