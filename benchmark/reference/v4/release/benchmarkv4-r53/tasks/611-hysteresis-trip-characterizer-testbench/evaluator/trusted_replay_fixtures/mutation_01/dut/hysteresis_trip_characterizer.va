`include "disciplines.vams"
module hysteresis_trip_characterizer(vdd, vss, vin, cmp_out, trip_rise, trip_fall, hyst_width, valid);
input vdd, vss, vin, cmp_out;
output trip_rise, trip_fall, hyst_width, valid;
electrical vdd, vss, vin, cmp_out, trip_rise, trip_fall, hyst_width, valid;
analog begin
    V(trip_rise, vss) <+ 0.0;
    V(trip_fall, vss) <+ 0.0;
    V(hyst_width, vss) <+ 0.0;
    V(valid, vss) <+ 0.0;
end
endmodule
