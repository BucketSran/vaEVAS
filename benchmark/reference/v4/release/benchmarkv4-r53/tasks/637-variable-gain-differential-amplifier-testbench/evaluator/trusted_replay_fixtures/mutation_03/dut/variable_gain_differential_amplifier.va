`include "disciplines.vams"
module variable_gain_differential_amplifier(sigin_p, sigin_n, sigctrl_p, sigctrl_n, sigout);
input sigin_p, sigin_n, sigctrl_p, sigctrl_n; output sigout; electrical sigin_p, sigin_n, sigctrl_p, sigctrl_n, sigout;
analog begin V(sigout)<+2.0*V(sigctrl_p,sigctrl_n)*V(sigin_p,sigin_n)+0.2; end
endmodule
