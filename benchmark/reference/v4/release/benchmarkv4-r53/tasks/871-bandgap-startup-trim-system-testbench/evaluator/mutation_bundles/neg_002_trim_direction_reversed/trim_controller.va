`include "constants.vams"
`include "disciplines.vams"

module trim_controller(clk, rst, trim_req, startup_en, core_ref, trim_3, trim_2, trim_1, trim_0, trim_corr, ready, error_metric);
    input clk, rst, trim_req, startup_en, core_ref;
    output trim_3, trim_2, trim_1, trim_0, trim_corr, ready, error_metric;
    electrical clk, rst, trim_req, startup_en, core_ref, trim_3, trim_2, trim_1, trim_0, trim_corr, ready, error_metric;

    parameter real vhi = 0.9;
    parameter real vlo = 0.0;
    parameter real vref_nom = 0.6;
    parameter real trim_lsb = 2e-3;
    parameter real ready_tol = 5e-3;
    parameter real vth = 0.45;
    parameter real tr = 200p from (0:inf);

    integer trim_code;
    integer ready_count;
    real corr_value;
    real err_value;
    real ready_value;

    analog begin
        @(initial_step) begin
            trim_code = 0;
            ready_count = 0;
            ready_value = vlo;
        end

        @(cross(V(clk) - vth, +1)) begin
            err_value = vref_nom - (V(core_ref) + trim_code * trim_lsb);
            if ((V(rst) > vth) || (V(startup_en) <= vth)) begin
                trim_code = 0;
                ready_count = 0;
                ready_value = vlo;
            end else if (V(trim_req) > vth) begin
                if ((err_value > ready_tol) && (trim_code > 0))
                    trim_code = trim_code - 1;
                else if ((err_value < -ready_tol) && (trim_code < 15))
                    trim_code = trim_code + 1;

                err_value = vref_nom - (V(core_ref) + trim_code * trim_lsb);
                if ((err_value <= ready_tol) && (err_value >= -ready_tol)) begin
                    if (ready_count < 3)
                        ready_count = ready_count + 1;
                    if (ready_count >= 3)
                        ready_value = vhi;
                end else begin
                    ready_count = 0;
                    ready_value = vlo;
                end
            end
        end

        corr_value = trim_code * trim_lsb;
        err_value = vref_nom - (V(core_ref) + corr_value);
        if ((V(rst) > vth) || (V(startup_en) <= vth)) begin
            corr_value = 0.0;
            err_value = 0.0;
        end

        V(trim_corr) <+ corr_value;
        V(error_metric) <+ err_value;
        V(ready) <+ transition(ready_value, 0, tr, tr);
        V(trim_0) <+ transition((trim_code % 2) ? vhi : vlo, 0, tr, tr);
        V(trim_1) <+ transition(((trim_code / 2) % 2) ? vhi : vlo, 0, tr, tr);
        V(trim_2) <+ transition(((trim_code / 4) % 2) ? vhi : vlo, 0, tr, tr);
        V(trim_3) <+ transition(((trim_code / 8) % 2) ? vhi : vlo, 0, tr, tr);
    end
endmodule
