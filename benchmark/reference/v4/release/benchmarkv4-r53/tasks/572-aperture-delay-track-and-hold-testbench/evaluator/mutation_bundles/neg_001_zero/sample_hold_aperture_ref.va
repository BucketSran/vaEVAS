`include "constants.vams"
`include "disciplines.vams"

module sample_hold_aperture_ref (
    inout  electrical VDD,
    inout  electrical VSS,
    input  electrical clk,
    input  electrical vin,
    output electrical vout
);
    parameter real vth = 0.45;
    parameter real taperture = 200p from [0:inf);
    parameter real tedge = 50p from (0:inf);

    real vh;
    real vl;
    real sampled;
    real sample_t;
    integer armed;

    analog begin
        V(vout) <+ transition(0.0);
    end
endmodule
