`include "disciplines.vams"

module smooth_comparator_tanh (sigin, sigref, sigout);

input sigin, sigref;
output sigout;
electrical sigin, sigref, sigout;

analog begin
    V(sigout) <+ 0;
end

endmodule
