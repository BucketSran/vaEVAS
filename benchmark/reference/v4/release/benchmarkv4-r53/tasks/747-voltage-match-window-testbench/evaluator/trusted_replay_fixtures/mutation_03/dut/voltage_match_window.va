`include "disciplines.vams"
module voltage_match_window(vin1, vin2, vout);
input vin1, vin2;
output vout;
electrical vin1, vin2, vout;
analog begin
    V(vout) <+ 0.0;
end
endmodule
