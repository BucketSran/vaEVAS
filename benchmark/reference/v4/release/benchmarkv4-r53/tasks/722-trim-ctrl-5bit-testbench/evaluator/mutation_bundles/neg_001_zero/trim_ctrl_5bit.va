`include "disciplines.vams"
module trim_ctrl_5bit(ain, dout0, dout1, dout2, dout3, dout4);
input ain;
output dout0, dout1, dout2, dout3, dout4;
electrical ain, dout0, dout1, dout2, dout3, dout4;
analog begin
    V(dout0) <+ 0.0;
    V(dout1) <+ 0.0;
    V(dout2) <+ 0.0;
    V(dout3) <+ 0.0;
    V(dout4) <+ 0.0;
end
endmodule
