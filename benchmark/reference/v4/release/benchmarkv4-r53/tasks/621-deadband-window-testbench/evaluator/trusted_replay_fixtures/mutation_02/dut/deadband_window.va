`include "disciplines.vams"

module deadband_window (sigin, sigout);

input sigin;
output sigout;
electrical sigin, sigout;

analog begin
    V(sigout) <+ 0;
end

endmodule
