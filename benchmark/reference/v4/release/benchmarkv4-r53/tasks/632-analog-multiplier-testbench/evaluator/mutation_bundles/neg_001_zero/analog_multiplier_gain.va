`include "disciplines.vams"

module analog_multiplier_gain (sigin1, sigin2, sigout);

input sigin1, sigin2;
output sigout;
electrical sigin1, sigin2, sigout;

analog begin
    V(sigout) <+ 0;
end

endmodule
