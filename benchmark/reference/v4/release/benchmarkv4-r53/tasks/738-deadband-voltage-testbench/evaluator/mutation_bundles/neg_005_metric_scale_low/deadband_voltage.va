// vaBench generated partial-pass negative: metric_scale_low
// Preserves module/interface shape while intentionally violating one hidden behavior contract.
`include "disciplines.vams"
module deadband_voltage(sigin, sigout);
input sigin;
output sigout;
electrical sigin, sigout;
parameter real sigin_dead_low = -0.25;
parameter real sigin_dead_high = 0.25;
analog begin
    if (V(sigin) < sigin_dead_low)
        V(sigout) <+ (0.42 * (V(sigin) - sigin_dead_low));
    else if (V(sigin) > sigin_dead_high)
        V(sigout) <+ V(sigin) - sigin_dead_high;
    else
        V(sigout) <+ 0.0;
end
endmodule
