`include "disciplines.vams"
module deadband_voltage(sigin, sigout);
input sigin;
output sigout;
electrical sigin, sigout;
analog begin
    V(sigout) <+ 0.0;
end
endmodule
