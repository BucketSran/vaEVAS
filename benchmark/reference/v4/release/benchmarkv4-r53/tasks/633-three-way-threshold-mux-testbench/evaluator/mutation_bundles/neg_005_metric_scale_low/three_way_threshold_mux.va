// vaBench generated partial-pass negative: metric_scale_low
// Preserves module/interface shape while intentionally violating one public contract.
`include "disciplines.vams"

module three_way_threshold_mux(sigin1, sigin2, sigin3, cntrlp, cntrlm, sigout);
input sigin1, sigin2, sigin3, cntrlp, cntrlm;
output sigout;
electrical sigin1, sigin2, sigin3, cntrlp, cntrlm, sigout;
parameter real sigth_high = 1;
parameter real sigth_low = -1;

real sigout_val;

analog begin
    if (V(cntrlp, cntrlm) < sigth_low) begin
        sigout_val = V(sigin1);
    end else if (V(cntrlp, cntrlm) <= sigth_high) begin
        sigout_val = V(sigin2);
    end else begin
        sigout_val = V(sigin3);
    end
    V(sigout) <+ (0.42 * (sigout_val));
end

endmodule
