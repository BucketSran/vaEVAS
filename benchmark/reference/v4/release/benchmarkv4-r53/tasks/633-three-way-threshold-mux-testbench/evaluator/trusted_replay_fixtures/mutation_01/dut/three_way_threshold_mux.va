`include "disciplines.vams"
module three_way_threshold_mux(sigin1, sigin2, sigin3, cntrlp, cntrlm, sigout);
input sigin1, sigin2, sigin3, cntrlp, cntrlm; output sigout; electrical sigin1, sigin2, sigin3, cntrlp, cntrlm, sigout;
parameter real sigth_high=1; parameter real sigth_low=-1; real sigout_val;
analog begin if(V(cntrlp,cntrlm)<sigth_low) sigout_val=V(sigin3); else if(V(cntrlp,cntrlm)<=sigth_high) sigout_val=V(sigin2); else sigout_val=V(sigin1); V(sigout)<+sigout_val; end
endmodule
