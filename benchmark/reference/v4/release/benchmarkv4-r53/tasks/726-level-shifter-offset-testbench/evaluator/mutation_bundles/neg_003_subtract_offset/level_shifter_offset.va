`include "disciplines.vams"
module level_shifter_offset(sigin, sigout);
input sigin;
output sigout;
electrical sigin, sigout;
parameter real sigshift = 0.35;
analog begin
    V(sigout) <+ V(sigin) + (0.0 - sigshift);
end
endmodule
