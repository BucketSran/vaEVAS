`include "disciplines.vams"

module four_channel_edge_sampler(clk, vin0, vin1, vin2, vin3, vout0, vout1, vout2, vout3);
input clk, vin0, vin1, vin2, vin3;
output vout0, vout1, vout2, vout3;
electrical clk, vin0, vin1, vin2, vin3, vout0, vout1, vout2, vout3;

analog begin
    V(vout0) <+ 0;
    V(vout1) <+ 0;
    V(vout2) <+ 0;
    V(vout3) <+ 0;
end

endmodule
