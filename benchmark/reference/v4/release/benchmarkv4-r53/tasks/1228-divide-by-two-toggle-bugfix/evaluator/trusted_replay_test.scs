simulator lang=spectre
global 0

ahdl_include "../submission/divide_by_two_toggle.va"

Vclk (clk 0) vsource type=pwl wave=[0 0 0.22n 0 0.24n 0.9 0.47n 0.9 0.49n 0 0.95n 0 0.97n 0.9 1.20n 0.9 1.22n 0 1.70n 0 1.72n 0.9 1.95n 0.9 1.97n 0 2.62n 0 2.64n 0.9 2.87n 0.9 2.89n 0 3.34n 0 3.36n 0.9 3.59n 0.9 3.61n 0 4.18n 0 4.20n 0.9 4.43n 0.9 4.45n 0 5.0n 0]
XDUT (clk out) divide_by_two_toggle

tran tran stop=4.9n maxstep=5p
save clk out
