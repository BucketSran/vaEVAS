`include "disciplines.vams"
module bin2ther_2b(vdd, gnd, b1, b0, t0, t1, t2);
input vdd, gnd, b1, b0;
output t0, t1, t2;
electrical vdd, gnd, b1, b0, t0, t1, t2;
analog begin
    V(t0) <+ 0.0;
    V(t1) <+ 0.0;
    V(t2) <+ 0.0;
end
endmodule
