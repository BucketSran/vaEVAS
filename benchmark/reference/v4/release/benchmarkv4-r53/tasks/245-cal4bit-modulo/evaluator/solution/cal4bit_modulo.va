`include "disciplines.vams"
module cal4bit_modulo(ain, d0, d1, d2, d3);
input ain;
output d0, d1, d2, d3;
electrical ain, d0, d1, d2, d3;
parameter real vh = 0.9;
integer code;
analog begin
    code = $floor(V(ain));
    if (code < 0) code = 0;
    if (code > 15) code = 15;
    V(d0) <+ transition((code & 1) ? vh : 0.0, 0, 10p, 10p);
    V(d1) <+ transition(((code >> 1) & 1) ? vh : 0.0, 0, 10p, 10p);
    V(d2) <+ transition(((code >> 2) & 1) ? vh : 0.0, 0, 10p, 10p);
    V(d3) <+ transition(((code >> 3) & 1) ? vh : 0.0, 0, 10p, 10p);
end
endmodule
