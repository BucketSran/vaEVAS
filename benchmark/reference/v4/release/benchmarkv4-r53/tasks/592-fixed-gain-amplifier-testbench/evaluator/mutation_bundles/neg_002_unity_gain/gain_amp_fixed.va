`include "constants.vams"
`include "disciplines.vams"
`default_transition 30p

module gain_amp_fixed(
    input  electrical VIN_P,
    input  electrical VIN_N,
    output electrical VOUT_P,
    output electrical VOUT_N
);

parameter real vdd         = 0.9;
parameter real ACTUAL_GAIN = 8.64;

analog begin
    V(VOUT_P) <+ V(VIN_P);
    V(VOUT_N) <+ V(VIN_N);
end

endmodule
