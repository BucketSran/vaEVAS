`include "disciplines.vams"

module latched_comparator_delay (DOUT, GND, VDD, CLK, VINN, VINP);

output DOUT;
electrical DOUT, GND, VDD, CLK, VINN, VINP;

analog begin
    V(DOUT) <+ 0;
end

endmodule
