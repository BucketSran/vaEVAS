`include "constants.vams"
`include "disciplines.vams"

module prbs7_ref(clk, rst_n, en, serial_out, state_0, state_1, state_2, state_3, state_4, state_5, state_6);
    input clk, rst_n, en;
    output serial_out, state_0, state_1, state_2, state_3, state_4, state_5, state_6;
    electrical clk, rst_n, en, serial_out, state_0, state_1, state_2, state_3, state_4, state_5, state_6;
    parameter real vdd = 0.9;
    parameter real vth = 0.45;
    parameter real trf = 10p;
    parameter real td = 0p;
    parameter integer seed = 127;
    integer s0, s1, s2, s3, s4, s5, s6, fb;
    analog begin
        @(initial_step) begin
            s0 = 1; s1 = 1; s2 = 1; s3 = 1; s4 = 1; s5 = 1; s6 = 1;
        end
        @(cross(V(clk) - vth, +1)) begin
            if (V(rst_n) < vth) begin
                s0 = 1; s1 = 1; s2 = 1; s3 = 1; s4 = 1; s5 = 1; s6 = 1;
            end else if (V(en) > vth) begin
                fb = s6 ^ s4;
                s6 = s5; s5 = s4; s4 = s3; s3 = s2; s2 = s1; s1 = s0; s0 = fb;
            end
        end
        V(serial_out) <+ transition(s6 ? vdd : 0.0, td, trf, trf);
        V(state_0) <+ transition(s0 ? vdd : 0.0, td, trf, trf);
        V(state_1) <+ transition(s1 ? vdd : 0.0, td, trf, trf);
        V(state_2) <+ transition(s2 ? vdd : 0.0, td, trf, trf);
        V(state_3) <+ transition(s3 ? vdd : 0.0, td, trf, trf);
        V(state_4) <+ transition(s4 ? vdd : 0.0, td, trf, trf);
        V(state_5) <+ transition(s5 ? vdd : 0.0, td, trf, trf);
        V(state_6) <+ transition(s6 ? vdd : 0.0, td, trf, trf);
    end
endmodule
