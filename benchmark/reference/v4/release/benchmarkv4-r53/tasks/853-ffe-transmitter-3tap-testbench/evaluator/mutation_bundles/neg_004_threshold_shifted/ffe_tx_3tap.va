`include "constants.vams"
`include "disciplines.vams"

module ffe_tx_3tap(data, clk, rst, pre_1, pre_0, post_1, post_0, vout, main_dbg, pre_dbg, post_dbg);
    input data, clk, rst, pre_1, pre_0, post_1, post_0;
    output vout, main_dbg, pre_dbg, post_dbg;
    electrical data, clk, rst, pre_1, pre_0, post_1, post_0, vout, main_dbg, pre_dbg, post_dbg;

    parameter real vdd = 0.9;
    parameter real vss = 0.0;
    parameter real vcm = 0.6;
    parameter real vth /*neg*/ = 0.6;
    parameter real main_amp = 0.18;
    parameter real tap_step = 0.04;
    parameter real tr = 120p from (0:inf);

    integer sym0;
    integer sym1;
    integer sym2;
    integer pre_code;
    integer post_code;
    real main_value;
    real pre_value;
    real post_value;
    real out_value;

    analog begin
        @(initial_step) begin
            sym0 = 0;
            sym1 = 0;
            sym2 = 0;
            main_value = vcm;
            pre_value = vcm;
            post_value = vcm;
            out_value = vcm;
        end

        @(cross(V(clk) - vth /*neg*/, +1)) begin
            if (V(rst) > vth /*neg*/) begin
                sym0 = 0;
                sym1 = 0;
                sym2 = 0;
                main_value = vcm;
                pre_value = vcm;
                post_value = vcm;
                out_value = vcm;
            end else begin
                sym2 = sym1;
                sym1 = sym0;
                sym0 = (V(data) > vth /*neg*/) ? 1 : -1;
                pre_code = 0;
                post_code = 0;
                if (V(pre_0) > vth /*neg*/) pre_code = pre_code + 1;
                if (V(pre_1) > vth /*neg*/) pre_code = pre_code + 2;
                if (V(post_0) > vth /*neg*/) post_code = post_code + 1;
                if (V(post_1) > vth /*neg*/) post_code = post_code + 2;
                main_value = vcm + main_amp * sym0;
                pre_value = vcm + tap_step * pre_code * sym1;
                post_value = vcm - tap_step * post_code * sym2;
                out_value = vcm + main_amp * sym0 + tap_step * pre_code * sym1 - tap_step * post_code * sym2;
                if (out_value > vdd)
                    out_value = vdd;
                if (out_value < vss)
                    out_value = vss;
            end
        end

        V(vout) <+ transition(out_value, 0, tr, tr);
        V(main_dbg) <+ transition(main_value, 0, tr, tr);
        V(pre_dbg) <+ transition(pre_value, 0, tr, tr);
        V(post_dbg) <+ transition(post_value, 0, tr, tr);
    end
endmodule
