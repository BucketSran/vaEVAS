`include "disciplines.vams"
        module linearity_rdac_offset_sweep(ck, d, vinp, vinn, vrefp, vrefn, dc0, dc1, dc2, dc3, dc4, dc5, dc6);
        input ck, d;
        output vinp, vinn, vrefp, vrefn, dc0, dc1, dc2, dc3, dc4, dc5, dc6;
        electrical ck, d, vinp, vinn, vrefp, vrefn, dc0, dc1, dc2, dc3, dc4, dc5, dc6;

analog begin
    V(vinp) <+ 0;
    V(vinn) <+ 0;
    V(vrefp) <+ 0;
    V(vrefn) <+ 0;
    V(dc0) <+ 0;
    V(dc1) <+ 0;
    V(dc2) <+ 0;
    V(dc3) <+ 0;
    V(dc4) <+ 0;
    V(dc5) <+ 0;
    V(dc6) <+ 0;
end
endmodule
