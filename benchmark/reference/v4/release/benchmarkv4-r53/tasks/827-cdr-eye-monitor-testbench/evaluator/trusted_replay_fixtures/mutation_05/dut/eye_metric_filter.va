`include "constants.vams"
`include "disciplines.vams"

module eye_metric_filter(sample_clk, rst, enable, margin, sample_valid, eye_metric, lock_hint);
    input sample_clk, rst, enable, margin, sample_valid;
    output eye_metric, lock_hint;
    electrical sample_clk, rst, enable, margin, sample_valid, eye_metric, lock_hint;

    parameter real vdd = 0.9;
    parameter real vss = 0.0;
    parameter real vth = 0.45;
    parameter real tr = 200p from (0:inf);
    parameter real eye_min = 0.55;

    integer good_count;
    real eye_v, lock_v;

    analog begin
        @(initial_step) begin
            good_count = 0;
            eye_v = vss;
            lock_v = vss;
        end

        @(cross(V(rst) - vth, +1) or cross(V(enable) - vth, -1)) begin
            good_count = 0;
            eye_v = vss;
            lock_v = vss;
        end

        @(cross(V(sample_clk) - vth, -1)) begin
            if (V(rst) > vth || V(enable) <= vth) begin
                good_count = 0;
                eye_v = vss;
                lock_v = vss;
            end else if (V(sample_valid) > vth) begin
                eye_v = V(margin);
                if (V(margin) > eye_min)
                    good_count = good_count + 1;
                else
                    good_count = 0;
                lock_v = (good_count >= 4) ? vdd : vss;
            end
        end

        V(eye_metric) <+ transition((V(rst) > vth || V(enable) <= vth) ? vdd : eye_v, 0, tr, tr);
        V(lock_hint) <+ transition(lock_v, 0, tr, tr);
    end
endmodule
