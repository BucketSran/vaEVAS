`include "disciplines.vams"
module comparator_offset_calibration_loop(vdd, vss, clk, dcmpp, vinp, vinn, offset_est, valid);
input vdd, vss, clk, dcmpp;
output vinp, vinn, offset_est, valid;
electrical vdd, vss, clk, dcmpp, vinp, vinn, offset_est, valid;
analog begin
    V(vinp, vss) <+ 0.0;
    V(vinn, vss) <+ 0.0;
    V(offset_est, vss) <+ 0.0;
    V(valid, vss) <+ 0.0;
end
endmodule
