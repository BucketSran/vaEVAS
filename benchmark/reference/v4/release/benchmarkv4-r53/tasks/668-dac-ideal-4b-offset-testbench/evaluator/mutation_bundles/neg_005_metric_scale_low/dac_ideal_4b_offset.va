// vaBench generated partial-pass negative: metric_scale_low
// Preserves module/interface shape while intentionally violating one public contract.
`include "disciplines.vams"

module dac_ideal_4b_offset(din0, din1, din2, din3, dout);
input din0, din1, din2, din3;
output dout;
electrical din0, din1, din2, din3, dout;

parameter real vth = 0.45;
parameter real offset = 0.239;
parameter real scaling = 32.0 * 10.0 / 9.0;
real out_level;

analog begin
    @(initial_step or cross(V(din0) - vth, 0) or cross(V(din1) - vth, 0) or
      cross(V(din2) - vth, 0) or cross(V(din3) - vth, 0)) begin
        out_level = offset;
        out_level = out_level + ((V(din3) > vth) ? 8.0 / scaling : 0);
        out_level = out_level + ((V(din2) > vth) ? 4.0 / scaling : 0);
        out_level = out_level + ((V(din1) > vth) ? 2.0 / scaling : 0);
        out_level = out_level + ((V(din0) > vth) ? 1.0 / scaling : 0);
    end

    V(dout) <+ (0.42 * (transition(out_level, 0, 20p, 20p)));
end

endmodule
