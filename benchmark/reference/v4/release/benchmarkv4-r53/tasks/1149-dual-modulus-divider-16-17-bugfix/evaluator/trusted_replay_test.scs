simulator lang=spectre
global 0

ahdl_include "../submission/dual_modulus_divider_16_17.va"

Vfin (fin 0) vsource type=pwl wave=[0 0 1n 0 1.05n 0.9 1.45n 0.9 1.5n 0 3n 0 3.05n 0.9 3.45n 0.9 3.5n 0 5n 0 5.05n 0.9 5.45n 0.9 5.5n 0 7n 0 7.05n 0.9 7.45n 0.9 7.5n 0 9n 0 9.05n 0.9 9.45n 0.9 9.5n 0 11n 0 11.05n 0.9 11.45n 0.9 11.5n 0 13n 0 13.05n 0.9 13.45n 0.9 13.5n 0 15n 0 15.05n 0.9 15.45n 0.9 15.5n 0 17n 0 17.05n 0.9 17.45n 0.9 17.5n 0 19n 0 19.05n 0.9 19.45n 0.9 19.5n 0 21n 0 21.05n 0.9 21.45n 0.9 21.5n 0 23n 0 23.05n 0.9 23.45n 0.9 23.5n 0 25n 0 25.05n 0.9 25.45n 0.9 25.5n 0 27n 0 27.05n 0.9 27.45n 0.9 27.5n 0 29n 0 29.05n 0.9 29.45n 0.9 29.5n 0 31n 0 31.05n 0.9 31.45n 0.9 31.5n 0 33n 0 33.05n 0.9 33.45n 0.9 33.5n 0 35n 0 35.05n 0.9 35.45n 0.9 35.5n 0 37n 0 37.05n 0.9 37.45n 0.9 37.5n 0 39n 0 39.05n 0.9 39.45n 0.9 39.5n 0 41n 0 41.05n 0.9 41.45n 0.9 41.5n 0 43n 0 43.05n 0.9 43.45n 0.9 43.5n 0 45n 0 45.05n 0.9 45.45n 0.9 45.5n 0 47n 0 47.05n 0.9 47.45n 0.9 47.5n 0 49n 0 49.05n 0.9 49.45n 0.9 49.5n 0 51n 0 51.05n 0.9 51.45n 0.9 51.5n 0 53n 0 53.05n 0.9 53.45n 0.9 53.5n 0 55n 0 55.05n 0.9 55.45n 0.9 55.5n 0 57n 0 57.05n 0.9 57.45n 0.9 57.5n 0 59n 0 59.05n 0.9 59.45n 0.9 59.5n 0 61n 0 61.05n 0.9 61.45n 0.9 61.5n 0 63n 0 63.05n 0.9 63.45n 0.9 63.5n 0 65n 0 65.05n 0.9 65.45n 0.9 65.5n 0 67n 0 67.05n 0.9 67.45n 0.9 67.5n 0 69n 0 69.05n 0.9 69.45n 0.9 69.5n 0 71n 0 71.05n 0.9 71.45n 0.9 71.5n 0 73n 0 73.05n 0.9 73.45n 0.9 73.5n 0 75n 0 75.05n 0.9 75.45n 0.9 75.5n 0 77n 0 77.05n 0.9 77.45n 0.9 77.5n 0 79n 0 79.05n 0.9 79.45n 0.9 79.5n 0 81n 0 81.05n 0.9 81.45n 0.9 81.5n 0 83n 0 83.05n 0.9 83.45n 0.9 83.5n 0 90n 0]
Vmc (mc 0) vsource type=pwl wave=[0 0 35n 0 35.1n 0.9 90n 0.9]
XDUT (fin mc fout) dual_modulus_divider_16_17

tran tran stop=90n maxstep=20p
save fin fout mc
