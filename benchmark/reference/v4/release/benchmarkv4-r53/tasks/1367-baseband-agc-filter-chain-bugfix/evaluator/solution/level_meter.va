`include "constants.vams"
`include "disciplines.vams"

module level_meter(vin, clk, rst, enable, level_metric);
    input vin, clk, rst, enable;
    output level_metric;
    electrical vin, clk, rst, enable, level_metric;

    parameter real vdd = 0.9;
    parameter real vss = 0.0;
    parameter real vcm = 0.45;
    parameter real vth = 0.45;
    parameter real tr = 200p from (0:inf);

    real level_value;
    real dev;

    analog begin
        @(initial_step) level_value = vss;

        @(cross(V(clk) - vth, +1)) begin
            if ((V(rst) > vth) || (V(enable) <= vth)) begin
                level_value = vss;
            end else begin
                dev = V(vin) - vcm;
                level_value = (dev < 0.0) ? -dev : dev;
            end
        end

        @(cross(V(rst) - vth, +1) or cross(V(enable) - vth, -1)) level_value = vss;

        V(level_metric) <+ transition(level_value, 0, tr, tr);
    end
endmodule
