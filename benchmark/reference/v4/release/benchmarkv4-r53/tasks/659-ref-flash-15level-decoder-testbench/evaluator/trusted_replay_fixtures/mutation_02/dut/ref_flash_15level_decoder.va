`include "disciplines.vams"

module ref_flash_15level_decoder(dt0, dt1, dt2, dt3, dt4, dt5, dt6, dt7, dt8, dt9, dt10, dt11, dt12, dt13, dt14, clks, dout);
input dt0, dt1, dt2, dt3, dt4, dt5, dt6, dt7, dt8, dt9, dt10, dt11, dt12, dt13, dt14, clks;
output dout;
electrical dt0, dt1, dt2, dt3, dt4, dt5, dt6, dt7, dt8, dt9, dt10, dt11, dt12, dt13, dt14, clks, dout;
//

analog begin
    V(dout) <+ 0;
end

endmodule
