`include "disciplines.vams"

module start_gated_offset_search (CLK, VOUT, START, VINP, VINN);

output VINP;
output VINN;
electrical CLK, VOUT, START, VINP, VINN;

analog begin
    V(VINP) <+ 0;
    V(VINN) <+ 0;
end

endmodule
