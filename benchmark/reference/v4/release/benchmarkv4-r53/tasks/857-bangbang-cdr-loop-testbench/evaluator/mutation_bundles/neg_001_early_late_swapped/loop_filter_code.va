`include "constants.vams"
`include "disciplines.vams"

module loop_filter_code(decision_clk, early, late, phase_error, rst, enable, phase_4, phase_3, phase_2, phase_1, phase_0, lock);
    input decision_clk, early, late, phase_error, rst, enable;
    output phase_4, phase_3, phase_2, phase_1, phase_0, lock;
    electrical decision_clk, early, late, phase_error, rst, enable, phase_4, phase_3, phase_2, phase_1, phase_0, lock;

    parameter real vdd = 0.9;
    parameter real vss = 0.0;
    parameter real vth = 0.45;
    parameter integer phase_center = 16;
    parameter integer lock_window = 2;
    parameter real tr = 200p;

    integer code;
    integer good_count;
    integer bad_count;
    integer locked;
    real abs_err;

    analog begin
        @(initial_step) begin
            code = phase_center;
            good_count = 0;
            bad_count = 0;
            locked = 0;
        end

        @(cross(V(rst) - vth, +1) or cross(V(enable) - vth, -1)) begin
            code = phase_center;
            good_count = 0;
            bad_count = 0;
            locked = 0;
        end

        @(cross(V(decision_clk) - vth, +1) or cross(V(decision_clk) - vth, -1)) begin
            if (V(rst) <= vth && V(enable) > vth) begin
                if (V(late) > vth && code < 31) code = code + 1;
                if (V(early) > vth && code > 0) code = code - 1;

                abs_err = V(phase_error);
                if (abs_err < 0.0) abs_err = -abs_err;
                if (abs_err <= lock_window) begin
                    good_count = good_count + 1;
                    bad_count = 0;
                    if (good_count >= 4) locked = 1;
                end else begin
                    good_count = 0;
                    if (locked != 0) begin
                        bad_count = bad_count + 1;
                        if (bad_count >= 2) locked = 0;
                    end
                end
            end
        end

        V(phase_4) <+ transition(((code / 16) % 2) ? vdd : vss, 0, tr, tr);
        V(phase_3) <+ transition(((code / 8) % 2) ? vdd : vss, 0, tr, tr);
        V(phase_2) <+ transition(((code / 4) % 2) ? vdd : vss, 0, tr, tr);
        V(phase_1) <+ transition(((code / 2) % 2) ? vdd : vss, 0, tr, tr);
        V(phase_0) <+ transition((code % 2) ? vdd : vss, 0, tr, tr);
        V(lock) <+ transition(locked ? vdd : vss, 0, tr, tr);
    end
endmodule
