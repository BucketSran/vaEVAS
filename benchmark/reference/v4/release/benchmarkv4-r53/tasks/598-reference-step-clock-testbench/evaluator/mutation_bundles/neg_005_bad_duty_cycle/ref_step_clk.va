`include "constants.vams"
`include "disciplines.vams"

module ref_step_clk (
    inout  electrical VDD,
    inout  electrical VSS,
    output electrical CLK
);
    parameter real period_pre = 20n from (0:inf);
    parameter real period_post = 19.5n from (0:inf);
    parameter real t_switch = 2u from [0:inf);
    parameter real tedge = 100p from (0:inf);

    real next_t;
    real period_now;
    integer clk_state;

    analog begin
        @(initial_step) begin
            clk_state = 0;
            period_now = period_pre;
            next_t = $abstime + 0.3 * period_now;
        end

        @(timer(next_t)) begin
            clk_state = 1 - clk_state;
            if (next_t >= t_switch) begin
                period_now = period_post;
            end else begin
                period_now = period_pre;
            end
            if (clk_state == 1) begin
                next_t = next_t + 0.7 * period_now;
            end else begin
                next_t = next_t + 0.3 * period_now;
            end
        end

        V(CLK) <+ V(VSS) + (V(VDD) - V(VSS)) * transition(clk_state ? 1.0 : 0.0, 0.0, tedge, tedge);
    end
endmodule
