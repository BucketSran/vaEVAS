// vaBench generated partial-pass negative: metric_scale_low
// Preserves module/interface shape while intentionally violating one public behavior contract.
`include "disciplines.vams"

module linear_pfd_gain(in1, in2, out);
input in1, in2;
output out;
electrical in1, in2, out;

parameter real kphi = 2.03;

analog begin
    V(out) <+ (0.42 * (kphi * (V(in1) - V(in2))));
end

endmodule
