`include "disciplines.vams"

module ideal_differential_opamp (vinp, vinn, voutp, voutn);

input vinp, vinn;
output voutp, voutn;
electrical vinp, vinn, voutp, voutn;

analog begin
    V(voutp) <+ 0;
    V(voutn) <+ 0;
end

endmodule
