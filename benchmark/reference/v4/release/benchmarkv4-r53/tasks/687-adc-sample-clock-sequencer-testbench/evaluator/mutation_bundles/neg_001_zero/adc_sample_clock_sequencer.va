`include "disciplines.vams"
        module adc_sample_clock_sequencer(rst, s, ss, nc_az, nc, conv);
        output rst, s, ss, nc_az, nc, conv;
        electrical rst, s, ss, nc_az, nc, conv;

analog begin
    V(rst) <+ 0;
    V(s) <+ 0;
    V(ss) <+ 0;
    V(nc_az) <+ 0;
    V(nc) <+ 0;
    V(conv) <+ 0;
end
endmodule
