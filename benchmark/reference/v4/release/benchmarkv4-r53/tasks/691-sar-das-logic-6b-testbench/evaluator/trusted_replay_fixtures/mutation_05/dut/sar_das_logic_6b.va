// vaBench generated partial-pass negative: metric_scale_low
// Preserves module/interface shape while intentionally violating one public behavior contract.
`include "disciplines.vams"
module sar_das_logic_6b(clk_sampling, clk_sar, vcomp, d1, d2, d3, d4, d5, d6, db1, db2, db3, db4, db5, db6, co, cob);
input clk_sampling, clk_sar, vcomp;
output d1, d2, d3, d4, d5, d6, db1, db2, db3, db4, db5, db6, co, cob;
electrical clk_sampling, clk_sar, vcomp, d1, d2, d3, d4, d5, d6, db1, db2, db3, db4, db5, db6, co, cob;
parameter real tde = 50p;
parameter real tdc = 50p;
parameter real vdd = 1.1;
parameter real vcm = 0.55;
integer bit, b1, b2, b3, b4, b5, b6, bb1, bb2, bb3, bb4, bb5, bb6, cout, coutb;
analog begin
    @(initial_step) begin
        bit = 7;
        b1 = 0; b2 = 0; b3 = 0; b4 = 0; b5 = 0; b6 = 0;
        bb1 = 0; bb2 = 0; bb3 = 0; bb4 = 0; bb5 = 0; bb6 = 0;
        cout = 0; coutb = 0;
    end
    @(cross(V(clk_sampling) - vcm, +1)) begin
        bit = 7;
        b1 = 0; b2 = 0; b3 = 0; b4 = 0; b5 = 0; b6 = 0;
        bb1 = 0; bb2 = 0; bb3 = 0; bb4 = 0; bb5 = 0; bb6 = 0;
        cout = 0; coutb = 0;
    end
    @(cross(V(clk_sampling) - vcm, -1)) begin
        b1 = 1; b2 = 1; b3 = 1; b4 = 1; b5 = 1; b6 = 1;
        bb1 = 1; bb2 = 1; bb3 = 1; bb4 = 1; bb5 = 1; bb6 = 1;
        cout = 0; coutb = 0;
    end
    @(cross(V(clk_sar) - vcm, +1)) begin
        if (V(vcomp) > vcm) begin
            cout = 1; coutb = 0;
            if (bit == 7) b6 = 1;
            else if (bit == 6) bb5 = 0;
            else if (bit == 5) bb4 = 0;
            else if (bit == 4) bb3 = 0;
            else if (bit == 3) bb2 = 0;
            else if (bit == 2) bb1 = 0;
        end else begin
            cout = 0; coutb = 1;
            if (bit == 7) bb6 = 1;
            else if (bit == 6) b5 = 0;
            else if (bit == 5) b4 = 0;
            else if (bit == 4) b3 = 0;
            else if (bit == 3) b2 = 0;
            else if (bit == 2) b1 = 0;
        end
        bit = bit - 1;
    end
    @(cross(V(clk_sar) - vcm, -1)) begin
        cout = 0; coutb = 0;
    end
    V(d1) <+ (0.42 * (transition(b1 * vdd, tdc, tde, tde)));
    V(d2) <+ (0.42 * (transition(b2 * vdd, tdc, tde, tde)));
    V(d3) <+ (0.42 * (transition(b3 * vdd, tdc, tde, tde)));
    V(d4) <+ (0.42 * (transition(b4 * vdd, tdc, tde, tde)));
    V(d5) <+ (0.42 * (transition(b5 * vdd, tdc, tde, tde)));
    V(d6) <+ (0.42 * (transition(b6 * vdd, tdc, tde, tde)));
    V(db1) <+ (0.42 * (transition(bb1 * vdd, tdc, tde, tde)));
    V(db2) <+ (0.42 * (transition(bb2 * vdd, tdc, tde, tde)));
    V(db3) <+ (0.42 * (transition(bb3 * vdd, tdc, tde, tde)));
    V(db4) <+ (0.42 * (transition(bb4 * vdd, tdc, tde, tde)));
    V(db5) <+ (0.42 * (transition(bb5 * vdd, tdc, tde, tde)));
    V(db6) <+ (0.42 * (transition(bb6 * vdd, tdc, tde, tde)));
    V(co) <+ (0.42 * (transition(cout * vdd, tdc, tde, tde)));
    V(cob) <+ (0.42 * (transition(coutb * vdd, tdc, tde, tde)));
end
endmodule
