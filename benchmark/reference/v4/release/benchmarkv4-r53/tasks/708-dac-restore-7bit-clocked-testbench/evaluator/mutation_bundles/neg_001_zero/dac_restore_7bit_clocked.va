`include "disciplines.vams"
module dac_restore_7bit_clocked(d6, d5, d4, d3, d2, d1, d0, clk, rst, vout);
input d6, d5, d4, d3, d2, d1, d0, clk, rst;
output vout;
electrical d6, d5, d4, d3, d2, d1, d0, clk, rst, vout;
analog begin
    V(vout) <+ 0.0;
end
endmodule
