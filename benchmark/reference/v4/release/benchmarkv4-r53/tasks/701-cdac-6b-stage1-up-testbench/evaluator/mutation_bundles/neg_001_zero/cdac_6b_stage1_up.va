`include "disciplines.vams"
        module cdac_6b_stage1_up(vin, clks, dctrl0, dctrl1, dctrl2, dctrl3, dctrl4, dctrl5, vres);
        input vin, clks, dctrl0, dctrl1, dctrl2, dctrl3, dctrl4, dctrl5;
        output vres;
        electrical vin, clks, dctrl0, dctrl1, dctrl2, dctrl3, dctrl4, dctrl5, vres;

analog begin
    V(vres) <+ 0;
end
endmodule
