`include "disciplines.vams"

module two_period_sample_delay(update, ain, aout);
input update, ain;
output aout;
electrical update, ain, aout;

analog begin
    V(aout) <+ 0;
end

endmodule
