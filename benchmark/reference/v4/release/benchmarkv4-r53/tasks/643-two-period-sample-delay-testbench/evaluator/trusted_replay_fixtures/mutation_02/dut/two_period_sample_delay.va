`include "disciplines.vams"
module two_period_sample_delay(update, ain, aout);
input update,ain; output aout; electrical update,ain,aout; parameter real vth=0.5; parameter real tr=50p; parameter real init=0.0; real delayed_out;
analog begin @(initial_step) delayed_out=init; @(cross(V(update)-vth,+1)) delayed_out=V(ain); V(aout)<+transition(delayed_out,0,tr,tr); end
endmodule
