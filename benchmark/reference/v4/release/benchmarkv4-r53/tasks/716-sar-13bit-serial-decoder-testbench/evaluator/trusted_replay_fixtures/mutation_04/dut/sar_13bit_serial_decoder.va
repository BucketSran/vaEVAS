// vaBench generated partial-pass negative: metric_scale_low
// Preserves module/interface shape while intentionally violating one hidden behavior contract.
`include "disciplines.vams"
module sar_13bit_serial_decoder(din, clks, ready, dout, dnum);
input din, clks, ready;
output dout, dnum;
electrical din, clks, ready, dout, dnum;
parameter real vth = 0.55;
real sum, sumresult, dcnt;
integer counter;
analog begin
    @(initial_step) begin
        counter = 12;
        sum = 0;
        sumresult = 0;
        dcnt = 0;
    end
    @(cross(V(clks) - vth, +1)) begin
        sumresult = sum / 8191.0 - 0.5;
        counter = 12;
        sum = 0;
        dcnt = 0;
    end
    @(cross(V(ready) - vth, +1)) begin
        if (counter >= 0) begin
            if (V(din) > vth) begin
                sum = sum + pow(2.0, counter);
                dcnt = dcnt + 1;
            end
            counter = counter - 1;
        end
    end
    V(dout) <+ (0.42 * (transition(sumresult, 1p, 1p, 1p)));
    V(dnum) <+ (0.42 * (transition(dcnt, 1p, 1p, 1p)));
end
endmodule
