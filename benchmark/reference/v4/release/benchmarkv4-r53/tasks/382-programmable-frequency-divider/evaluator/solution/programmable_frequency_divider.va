`include "constants.vams"
`include "disciplines.vams"

module programmable_frequency_divider(clk_in, rst, enable, n_3, n_2, n_1, n_0, clk_div, ratio_metric, valid);
    input clk_in, rst, enable, n_3, n_2, n_1, n_0;
    output clk_div, ratio_metric, valid;
    electrical clk_in, rst, enable, n_3, n_2, n_1, n_0, clk_div, ratio_metric, valid;

    parameter real vdd = 0.9;
    parameter real vss = 0.0;
    parameter real vth = 0.45;
    parameter real tr = 100p from (0:inf);

    integer count;
    integer divisor;
    integer out_state;
    integer valid_state;
    integer code;
    real metric_value;

    analog begin
        @(initial_step) begin
            count = 0;
            divisor = 1;
            out_state = 0;
            valid_state = 0;
            metric_value = vss;
        end

        @(cross(V(clk_in) - vth, +1) or cross(V(rst) - vth, +1) or
          cross(V(enable) - vth, -1)) begin
            if (V(rst) > vth || V(enable) <= vth) begin
                count = 0;
                divisor = 1;
                out_state = 0;
                valid_state = 0;
                metric_value = vss;
            end else begin
                code = 0;
                if (V(n_0) > vth) code = code + 1;
                if (V(n_1) > vth) code = code + 2;
                if (V(n_2) > vth) code = code + 4;
                if (V(n_3) > vth) code = code + 8;
                divisor = code + 1;
                metric_value = vdd * divisor / 16.0;
                if (count >= divisor - 1) begin
                    count = 0;
                    out_state = 1 - out_state;
                    valid_state = 1;
                end else begin
                    count = count + 1;
                end
            end
        end

        V(clk_div) <+ transition(out_state ? vdd : vss, 0, tr, tr);
        V(ratio_metric) <+ transition(metric_value, 0, tr, tr);
        V(valid) <+ transition(valid_state ? vdd : vss, 0, tr, tr);
    end
endmodule
