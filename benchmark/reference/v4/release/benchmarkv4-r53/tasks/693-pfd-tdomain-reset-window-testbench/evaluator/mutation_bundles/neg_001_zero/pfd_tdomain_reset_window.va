`include "disciplines.vams"
        module pfd_tdomain_reset_window(in1, in2, up, dn, vdd, gnd);
        input in1, in2, vdd, gnd;
        output up, dn;
        electrical in1, in2, up, dn, vdd, gnd;

analog begin
    V(up) <+ 0;
    V(dn) <+ 0;
end
endmodule
