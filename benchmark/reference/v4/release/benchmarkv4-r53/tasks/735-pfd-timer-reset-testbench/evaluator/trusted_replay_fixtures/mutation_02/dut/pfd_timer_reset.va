`include "disciplines.vams"
module pfd_timer_reset(a, b, ub, d);
input a, b;
output ub, d;
electrical a, b, ub, d;
analog begin
    V(ub) <+ 0.0;
    V(d) <+ 0.0;
end
endmodule
