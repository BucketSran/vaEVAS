`include "disciplines.vams"

module differential_deadband (sigin_p, sigin_n, sigout);

input sigin_p, sigin_n;
output sigout;
electrical sigin_p, sigin_n, sigout;

parameter real dead_high = 0.1;
parameter real dead_low = -0.1;
parameter real gain = 1;
parameter real leak = 0;

real diff;
real target;

analog begin
    diff = V(sigin_p, sigin_n);
    if (diff < dead_low) begin
        target = gain * (diff - dead_low) + leak;
    end else if (diff > dead_high) begin
        target = gain * (diff - dead_high) + leak;
    end else begin
        target = leak;
    end
    V(sigout) <+ target;
end

endmodule
