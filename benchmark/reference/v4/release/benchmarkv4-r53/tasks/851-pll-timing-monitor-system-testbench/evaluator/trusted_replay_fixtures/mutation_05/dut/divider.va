`include "constants.vams"
`include "disciplines.vams"

module divider(fb_clk, rst, enable, div2_clk);
    input fb_clk, rst, enable;
    output div2_clk;
    electrical fb_clk, rst, enable, div2_clk;

    parameter real vdd = 0.9;
    parameter real vss = 0.0;
    parameter real vth = 0.45;
    parameter real tr = 200p from (0:inf);

    integer edge_count;
    integer div_state;

    analog begin
        @(initial_step) begin
            edge_count = 0;
            div_state = 0;
        end

        @(cross(V(rst) - vth, +1) or cross(V(enable) - vth, -1)) begin
            edge_count = 0;
            div_state = 0;
        end

        @(cross(V(fb_clk) - vth, +1)) begin
            if (V(rst) > vth || V(enable) <= vth) begin
                edge_count = 0;
                div_state = 0;
            end else begin
                edge_count = edge_count + 1;
                if (edge_count >= 2) begin
                    edge_count = 0;
                    div_state = 1 - div_state;
                end
            end
        end

        V(div2_clk) <+ transition(div_state ? vdd : vss, 0, tr, tr);
    end
endmodule
