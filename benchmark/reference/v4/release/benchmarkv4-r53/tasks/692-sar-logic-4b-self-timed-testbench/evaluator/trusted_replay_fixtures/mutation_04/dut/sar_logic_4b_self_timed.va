`include "disciplines.vams"
        module sar_logic_4b_self_timed(vdd, gnd, clkc, rst, dcmpp, dcmpn, cmpck, dout1, dout2, dout3, dout4, dbotp1, dbotp2, dbotp3, dbotn1, dbotn2, dbotn3);
        input vdd, gnd, clkc, rst, dcmpp, dcmpn;
        output cmpck, dout1, dout2, dout3, dout4, dbotp1, dbotp2, dbotp3, dbotn1, dbotn2, dbotn3;
        electrical vdd, gnd, clkc, rst, dcmpp, dcmpn, cmpck, dout1, dout2, dout3, dout4, dbotp1, dbotp2, dbotp3, dbotn1, dbotn2, dbotn3;

analog begin
    V(cmpck) <+ 0;
    V(dout1) <+ 0;
    V(dout2) <+ 0;
    V(dout3) <+ 0;
    V(dout4) <+ 0;
    V(dbotp1) <+ 0;
    V(dbotp2) <+ 0;
    V(dbotp3) <+ 0;
    V(dbotn1) <+ 0;
    V(dbotn2) <+ 0;
    V(dbotn3) <+ 0;
end
endmodule
