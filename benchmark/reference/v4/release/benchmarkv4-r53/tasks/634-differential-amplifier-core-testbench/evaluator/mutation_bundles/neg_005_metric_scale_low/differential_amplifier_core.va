// vaBench generated partial-pass negative: metric_scale_low
// Preserves module/interface shape while intentionally violating one public contract.
`include "disciplines.vams"

module differential_amplifier_core(sigin_p, sigin_n, sigout);
input sigin_p, sigin_n;
output sigout;
electrical sigin_p, sigin_n, sigout;

real diff;

analog begin
    diff = V(sigin_p, sigin_n);
    V(sigout) <+ (0.42 * (2.0 * (diff - 0.05)));
end

endmodule
