`include "constants.vams"
`include "disciplines.vams"

module event_counter_windowed_16b(gate, event_in, done, count0, count1, count2, count3, count4, count5, count6, count7, count8, count9, count10, count11, count12, count13, count14, count15);
    input gate, event_in;
    output done, count0, count1, count2, count3, count4, count5, count6, count7, count8, count9, count10, count11, count12, count13, count14, count15;
    electrical gate, event_in, done, count0, count1, count2, count3, count4, count5, count6, count7, count8, count9, count10, count11, count12, count13, count14, count15;

    parameter real vdd = 0.9;
    parameter real vth = 0.45;
    parameter real tr = 20p;

    integer active; real done_level;
    analog begin
        @(initial_step) begin active=0; done_level=0; end
        @(cross(V(gate)-vth,+1)) begin active=1; done_level=0; end
        @(cross(V(event_in)-vth,+1)) begin if (active && V(gate)>vth) begin end end
        @(cross(V(gate)-vth,-1)) begin active=0; done_level=vdd; end
        V(done) <+ transition(done_level, 0, tr, tr);
        V(count0) <+ transition(0.0, 0, tr, tr);
        V(count1) <+ transition(0.0, 0, tr, tr);
        V(count2) <+ transition(0.0, 0, tr, tr);
        V(count3) <+ transition(0.0, 0, tr, tr);
        V(count4) <+ transition(0.0, 0, tr, tr);
        V(count5) <+ transition(0.0, 0, tr, tr);
        V(count6) <+ transition(0.0, 0, tr, tr);
        V(count7) <+ transition(0.0, 0, tr, tr);
        V(count8) <+ transition(0.0, 0, tr, tr);
        V(count9) <+ transition(0.0, 0, tr, tr);
        V(count10) <+ transition(0.0, 0, tr, tr);
        V(count11) <+ transition(0.0, 0, tr, tr);
        V(count12) <+ transition(0.0, 0, tr, tr);
        V(count13) <+ transition(0.0, 0, tr, tr);
        V(count14) <+ transition(0.0, 0, tr, tr);
        V(count15) <+ transition(0.0, 0, tr, tr);
    end
endmodule
