`include "constants.vams"
`include "disciplines.vams"

module bin_to_therm_8b(
    input electrical en,
    input electrical [7:0] b,
    output electrical [255:0] th
);
    parameter real vdd = 0.9;
    parameter real vth = 0.45;
    parameter real tr = 20p;

    integer code;
    genvar i;

    analog begin
        code = 0;
        for (i = 0; i < 8; i = i + 1) begin
            if (V(b[i]) > vth) code = code + (1 << i);
        end
        if (code > 0) code = code - 1;
        for (i = 0; i < 256; i = i + 1) begin
            V(th[i]) <+ slew(((V(en) > vth) && (i < code)) ? vdd : 0.0, 0.9 / (tr), -0.9 / (tr));
        end
    end
endmodule
