`include "disciplines.vams"
module decision_router_logic(vin1, vin2, valid, x, y, z, dm, dl);
input vin1, vin2, valid;
output x, y, z, dm, dl;
electrical vin1, vin2, valid, x, y, z, dm, dl;
analog begin
    V(x) <+ 0.0;
    V(y) <+ 0.0;
    V(z) <+ 0.0;
    V(dm) <+ 0.0;
    V(dl) <+ 0.0;
end
endmodule
