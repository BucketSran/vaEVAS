`include "disciplines.vams"
module therm8_to_bin4_count(th0, th1, th2, th3, th4, th5, th6, th7, b0, b1, b2, b3);
input th0, th1, th2, th3, th4, th5, th6, th7;
output b0, b1, b2, b3;
electrical th0, th1, th2, th3, th4, th5, th6, th7, b0, b1, b2, b3;
analog begin
    V(b0) <+ 0.0;
    V(b1) <+ 0.0;
    V(b2) <+ 0.0;
    V(b3) <+ 0.0;
end
endmodule
