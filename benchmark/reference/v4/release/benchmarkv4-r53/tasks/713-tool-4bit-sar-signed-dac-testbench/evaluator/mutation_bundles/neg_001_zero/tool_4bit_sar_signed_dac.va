`include "disciplines.vams"
module tool_4bit_sar_signed_dac(d0, d1, d2, d3, sh, aout);
input d0, d1, d2, d3, sh;
output aout;
electrical d0, d1, d2, d3, sh, aout;
analog begin
    V(aout) <+ 0.0;
end
endmodule
