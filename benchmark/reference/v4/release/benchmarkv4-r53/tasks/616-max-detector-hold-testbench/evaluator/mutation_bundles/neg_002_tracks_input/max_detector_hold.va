`include "disciplines.vams"
module max_detector_hold (vin, vout);
input vin; output vout; electrical vin, vout;
analog begin
    V(vout) <+ V(vin);
end
endmodule
