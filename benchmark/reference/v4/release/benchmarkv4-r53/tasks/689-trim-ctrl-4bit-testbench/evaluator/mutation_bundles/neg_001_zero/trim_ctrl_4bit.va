`include "disciplines.vams"
        module trim_ctrl_4bit(ain, dout0, dout1, dout2, dout3);
        input ain;
        output dout0, dout1, dout2, dout3;
        electrical ain, dout0, dout1, dout2, dout3;

analog begin
    V(dout0) <+ 0;
    V(dout1) <+ 0;
    V(dout2) <+ 0;
    V(dout3) <+ 0;
end
endmodule
