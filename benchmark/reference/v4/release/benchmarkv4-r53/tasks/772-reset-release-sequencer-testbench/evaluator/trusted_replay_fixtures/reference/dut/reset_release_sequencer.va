`include "disciplines.vams"

module reset_release_sequencer(clk, rst, supply_ok, bias_ok, stage1, stage2, ready, progress);
input clk, rst, supply_ok, bias_ok;
output stage1, stage2, ready, progress;
electrical clk, rst, supply_ok, bias_ok, stage1, stage2, ready, progress;

parameter real vth = 0.45;
parameter real vhi = 0.9;
parameter integer final_stage = 3;
parameter real tr = 60p;

integer stage_q;
real stage1_v;
real stage2_v;
real ready_v;
real progress_v;

analog function real clip01;
    input x;
    real x;
    begin
        if (x < 0.0) clip01 = 0.0;
        else if (x > 1.0) clip01 = 1.0;
        else clip01 = x;
    end
endfunction

analog function real clamp_range;
    input x;
    input lo;
    input hi;
    real x, lo, hi;
    begin
        if (x < lo) clamp_range = lo;
        else if (x > hi) clamp_range = hi;
        else clamp_range = x;
    end
endfunction

analog begin
    @(initial_step) begin
        stage_q = 0;
        stage1_v = 0.0;
        stage2_v = 0.0;
        ready_v = 0.0;
        progress_v = 0.0;
    end

    @(cross(V(clk) - vth, +1)) begin
        if ((V(rst) > vth) || (V(supply_ok) <= vth) || (V(bias_ok) <= vth)) begin
            stage_q = 0;
        end else if (stage_q < final_stage) begin
            stage_q = stage_q + 1;
        end
        stage1_v = (stage_q >= 1) ? vhi : 0.0;
        stage2_v = (stage_q >= 2) ? vhi : 0.0;
        ready_v = (stage_q >= final_stage) ? vhi : 0.0;
        progress_v = vhi * clip01((1.0 * stage_q) / final_stage);
    end

    V(stage1) <+ transition(stage1_v, 0.0, tr, tr);
    V(stage2) <+ transition(stage2_v, 0.0, tr, tr);
    V(ready) <+ transition(ready_v, 0.0, tr, tr);
    V(progress) <+ transition(progress_v, 0.0, tr, tr);
end
endmodule
