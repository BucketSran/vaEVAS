`include "disciplines.vams"

module safe_voltage_divider (signumer, sigdenom, sigout);

input signumer, sigdenom;
output sigout;
electrical signumer, sigdenom, sigout;

analog begin
    V(sigout) <+ 0;
end

endmodule
