`include "disciplines.vams"
        module foreground_rdac_calibrator(ck, d, vrefp, vrefn, dc0, dc1, dc2, dc3, dc4, dc5, dc6, cvinp, cvinn, en, enb);
        input ck, d, vrefp, vrefn;
        output dc0, dc1, dc2, dc3, dc4, dc5, dc6, cvinp, cvinn, en, enb;
        electrical ck, d, vrefp, vrefn, dc0, dc1, dc2, dc3, dc4, dc5, dc6, cvinp, cvinn, en, enb;

analog begin
    V(dc0) <+ 0;
    V(dc1) <+ 0;
    V(dc2) <+ 0;
    V(dc3) <+ 0;
    V(dc4) <+ 0;
    V(dc5) <+ 0;
    V(dc6) <+ 0;
    V(cvinp) <+ 0;
    V(cvinn) <+ 0;
    V(en) <+ 0;
    V(enb) <+ 0;
end

endmodule
