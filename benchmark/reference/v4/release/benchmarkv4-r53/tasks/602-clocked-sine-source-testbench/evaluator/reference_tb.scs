simulator lang=spectre
global 0

ahdl_include "./dut/vin_src.va"
ahdl_include "./dut/support/lfsr.va"
ahdl_include "./dut/support/dither_adder.va"
ahdl_include "./dut/support/gain_amp_fixed.va"

// gain_extraction smoke testbench
// 50 MHz clock, ACTUAL_GAIN=8.64, DITHER_AMP=0.014063. Run 2us.
// Check: std(vamp_diff) / std(vin_diff) > 4.0.
parameters vdd=0.9 ACTUAL_GAIN=8.64 DITHER_AMP=0.014063 fs=50e6 fin=1e6 VIN_NOISE=0.01
Vvdd (vdd 0) vsource dc=vdd
Vvss (vss 0) vsource dc=0
// 50 MHz clock
Vclk (clk 0) vsource type=pulse val0=0 val1=vdd period=20n delay=5n rise=1n fall=1n width=9n
// Reset deasserts at 40ns
Vrst_n (rst_n 0) vsource type=pwl wave=[0 0  39.5n 0  40n vdd  2u vdd]
Ven    (en    0) vsource dc=vdd
// Public support modules are mounted read-only from the declared support contract.
// Clocked noisy sine input plus public parameter-contract probes.
// A/B must agree for the same seed, ALT must respond to a different seed,
// and SIGMA0 must reduce to the sampled sine without perturbation.
IVIN_SEED_A (clk rst_n vinp vinn) vin_src vdd=vdd vth=0.45 ampl=0.02 freq=fin sigma=VIN_NOISE SEED=17
IVIN_SEED_B (clk rst_n vinp_seed_b vinn_seed_b) vin_src vdd=vdd vth=0.45 ampl=0.02 freq=fin sigma=VIN_NOISE SEED=17
IVIN_SEED_ALT (clk rst_n vinp_seed_alt vinn_seed_alt) vin_src vdd=vdd vth=0.45 ampl=0.02 freq=fin sigma=VIN_NOISE SEED=29
IVIN_SIGMA0 (clk rst_n vinp_sigma0 vinn_sigma0) vin_src vdd=vdd vth=0.45 ampl=0.02 freq=fin sigma=0 SEED=17
// LFSR (drives dither)
ILFSR (dpn vdd vss clk en rst_n) lfsr seed=42
// Dither adder
IDITH (vinp vinn dpn vdin_p vdin_n) dither_adder vdd=vdd vth=0.45 DITHER_AMP=DITHER_AMP
// Fixed-gain amplifier
IAMP  (vdin_p vdin_n vamp_p vamp_n) gain_amp_fixed vdd=vdd ACTUAL_GAIN=ACTUAL_GAIN

simulatorOptions options evas_profile=balanced

tran tran stop=2u maxstep=8n
save clk rst_n vinp vinn vamp_p vamp_n vinp_seed_b vinn_seed_b vinp_seed_alt vinn_seed_alt vinp_sigma0 vinn_sigma0
