`include "disciplines.vams"
module cal4bit_modulo(ain, d0, d1, d2, d3);
input ain;
output d0, d1, d2, d3;
electrical ain, d0, d1, d2, d3;
analog begin
    V(d0) <+ 0.0;
    V(d1) <+ 0.0;
    V(d2) <+ 0.0;
    V(d3) <+ 0.0;
end
endmodule
