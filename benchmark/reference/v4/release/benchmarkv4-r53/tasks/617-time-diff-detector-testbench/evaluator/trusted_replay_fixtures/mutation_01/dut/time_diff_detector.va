`include "disciplines.vams"

module time_diff_detector (clk, vinp, vinn, vout);

input clk, vinp, vinn;
output vout;
electrical clk, vinp, vinn, vout;

analog begin
    V(vout) <+ 0;
end

endmodule
