`include "disciplines.vams"

module divide_by_eight_clock(vin, rst, en, vout);
input vin, rst, en;
output vout;
electrical vin, rst, en, vout;

analog begin
    V(vout) <+ 0;
end

endmodule
