`include "constants.vams"
`include "disciplines.vams"

module por_detector (
    input  electrical vdd_sense,
    input  electrical clk,
    input  electrical rst_n_ext,
    output electrical por_n
);
    parameter real vhi = 0.9;
    parameter real vlo = 0.0;
    parameter real vpor = 0.72;
    parameter real vth = 0.45;
    parameter real tr = 200e-12;

    integer good_count;
    integer por_state;
    real por_target;

    analog begin
        @(initial_step) begin
            good_count = 0;
            por_state = 0;
        end

        @(cross(V(clk) - vth, +1)) begin
            if ((V(vdd_sense) >= vpor) && (V(rst_n_ext) > vth)) begin
                if (good_count < 2) begin
                    good_count = good_count + 1;
                end
                if (good_count >= 2) begin
                    por_state = 1;
                end
            end else if (V(rst_n_ext) <= vth) begin
                good_count = 0;
                por_state = 0;
            end else begin
                good_count = good_count;
                por_state = por_state;
            end
        end

        @(cross(V(rst_n_ext) - vth, -1)) begin
            good_count = 0;
            por_state = 0;
        end

        por_target = (por_state != 0) ? vhi : vlo;
        V(por_n) <+ transition(por_target, 0, tr);
    end
endmodule
