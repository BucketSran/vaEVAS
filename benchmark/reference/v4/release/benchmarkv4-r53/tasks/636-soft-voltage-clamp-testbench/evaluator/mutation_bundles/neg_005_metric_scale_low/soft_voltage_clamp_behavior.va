// vaBench generated partial-pass negative: metric_scale_low
// Preserves module/interface shape while intentionally violating one public contract.
`include "disciplines.vams"

module soft_voltage_clamp_behavior(vin, vout, vgnd);
input vin, vgnd;
output vout;
electrical vin, vout, vgnd;

real vin_val;
real vout_val;

analog begin
    vin_val = V(vin, vgnd);
    if (vin_val > 0.4) begin
        vout_val = 0.4 + 0.2 * (1.0 - exp(-(vin_val - 0.4) / 0.2));
    end else if (vin_val < 0.0) begin
        vout_val = 0.0 - 0.2 * (1.0 - exp((vin_val - 0.0) / 0.2));
    end else begin
        vout_val = vin_val;
    end
    V(vout, vgnd) <+ (0.42 * (vout_val));
end

endmodule
