simulator lang=spectre
global 0

ahdl_include "./dut/clocked_mux4_sampler.va"

Vclks (clks 0) vsource type=pwl wave=[0 0.9 1n 0.9 1.05n 0 1.5n 0 1.55n 0.9 3n 0.9 3.05n 0 3.5n 0 3.55n 0.9 5n 0.9 5.05n 0 5.5n 0 5.55n 0.9 7n 0.9 7.05n 0 7.5n 0 7.55n 0.9 9n 0.9 9.05n 0 9.5n 0 9.55n 0.9 11n 0.9 11.05n 0 11.5n 0 11.55n 0.9]
Vdsel0 (dsel0 0) vsource type=pwl wave=[0 0 2.8n 0 2.9n 0.9 6.8n 0.9 6.9n 0 10.8n 0 10.9n 0.9]
Vdsel1 (dsel1 0) vsource type=pwl wave=[0 0 6.8n 0 6.9n 0.9]
Vupdate (update 0) vsource type=pwl wave=[0 0.9 1.5n 0.9 1.6n 0 4.8n 0 4.9n 0.9]
Vrst (rst 0) vsource type=pwl wave=[0 0.9 0.7n 0.9 0.8n 0 8.6n 0 8.7n 0.9 9.3n 0.9 9.4n 0]
Vdin0 (din0 0) vsource type=pwl wave=[0 0.12 1.7n 0.12 1.8n 0.25]
Vdin1 (din1 0) vsource dc=0.34
Vdin2 (din2 0) vsource dc=0.61
Vdin3 (din3 0) vsource dc=0.83
XDUT (dsel0 dsel1 din0 din1 din2 din3 update rst clks dout) clocked_mux4_sampler

simulatorOptions options evas_profile=balanced

tran tran stop=12n maxstep=20p
save clks din0 din1 din2 din3 dout dsel0 dsel1 rst update
