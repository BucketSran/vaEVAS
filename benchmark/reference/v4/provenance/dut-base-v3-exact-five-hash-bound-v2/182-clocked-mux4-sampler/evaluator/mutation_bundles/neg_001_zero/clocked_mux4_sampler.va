`include "disciplines.vams"

        module clocked_mux4_sampler(dsel0, dsel1, din0, din1, din2, din3, update, rst, clks, dout);
        input dsel0, dsel1, din0, din1, din2, din3, update, rst, clks;
        output dout;
        electrical dsel0, dsel1, din0, din1, din2, din3, update, rst, clks, dout;

analog begin
    V(dout) <+ 0;
end

endmodule
