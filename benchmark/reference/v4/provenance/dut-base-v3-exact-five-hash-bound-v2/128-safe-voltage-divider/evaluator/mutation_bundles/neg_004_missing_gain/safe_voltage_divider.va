`include "disciplines.vams"
module safe_voltage_divider(signumer, sigdenom, sigout);
input signumer, sigdenom; output sigout; electrical signumer, sigdenom, sigout;
parameter real gain=1; parameter real min_sigdenom=1.0e-9 from (0:inf); real denominator;
analog begin denominator=V(sigdenom); if (abs(denominator)<min_sigdenom) denominator=(denominator>0.0)?min_sigdenom:-min_sigdenom; V(sigout)<+V(signumer)/denominator; end
endmodule
