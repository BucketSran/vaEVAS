`include "disciplines.vams"
        module l2_7b_dac_ready(din1, din2, din3, din4, din5, din6, din7, rdy, aout);
        input din1, din2, din3, din4, din5, din6, din7, rdy;
        output aout;
        electrical din1, din2, din3, din4, din5, din6, din7, rdy, aout;

analog begin
    V(aout) <+ 0;
end
endmodule
