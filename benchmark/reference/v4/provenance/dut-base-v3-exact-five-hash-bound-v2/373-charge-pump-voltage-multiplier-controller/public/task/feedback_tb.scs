simulator lang=spectre
global 0

ahdl_include "./dut/phase_generator.va"
ahdl_include "./dut/pump_stage_model.va"
ahdl_include "./dut/regulation_comparator.va"
ahdl_include "./dut/voltage_multiplier_top.va"

Vclk (clk 0) vsource type=pulse val0=0 val1=0.9 period=8n width=3n rise=100p fall=100p delay=1n
Vrst (rst 0) vsource type=pwl wave=[0 0.9 3n 0.9 3.2n 0 310n 0 310.2n 0.9 320n 0.9 320.2n 0]
Ven (enable 0) vsource type=pwl wave=[0 0 4n 0 4.2n 0.9 225n 0.9 225.2n 0 245n 0 245.2n 0.9 380n 0.9]
Vtarget (target 0) vsource type=pwl wave=[0 1.05 175n 1.05 175.2n 0.62 275n 0.62 275.2n 0.16 380n 0.16]
XDUT (clk rst enable target vout phase_a phase_b pump_en regulation_error ready) voltage_multiplier_top pump_step=0.04 leak_step=0.005 ready_tol=0.025

simulatorOptions options evas_profile=balanced

tran tran stop=380n maxstep=100p
save clk rst enable target vout phase_a phase_b pump_en regulation_error ready
