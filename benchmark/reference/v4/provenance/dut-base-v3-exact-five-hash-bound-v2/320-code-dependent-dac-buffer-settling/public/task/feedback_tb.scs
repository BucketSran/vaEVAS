simulator lang=spectre
global 0

ahdl_include "./dut/code_dependent_dac_buffer_top.va"
ahdl_include "./dut/ideal_code_dac.va"
ahdl_include "./dut/settling_buffer_state.va"

Vclk (clk 0) vsource type=pulse val0=0 val1=0.9 period=6n width=3n delay=1n rise=60p fall=60p
Vrst (rst 0) vsource type=pwl wave=[0 0.9 2.1n 0.9 2.2n 0 80n 0]
Venable (enable 0) vsource type=pwl wave=[0 0 5n 0 5.1n 0.9 56n 0.9 56.1n 0 62n 0 62.1n 0.9 80n 0.9]
Vcode_3 (code_3 0) vsource type=pwl wave=[0 0 9n 0 9.1n 0.9 25n 0.9 25.1n 0 43n 0 43.1n 0.9 80n 0.9]
Vcode_2 (code_2 0) vsource type=pwl wave=[0 0 8n 0 8.1n 0.9 24n 0.9 24.1n 0 42n 0 42.1n 0.9 80n 0.9]
Vcode_1 (code_1 0) vsource type=pwl wave=[0 0 11n 0 11.1n 0.9 27n 0.9 27.1n 0 45n 0 45.1n 0.9 80n 0.9]
Vcode_0 (code_0 0) vsource type=pwl wave=[0 0 10n 0 10.1n 0.9 26n 0.9 26.1n 0 44n 0 44.1n 0.9 80n 0.9]
XDUT (clk rst enable code_3 code_2 code_1 code_0 vout target_dbg settling_metric settled) code_dependent_dac_buffer_top

simulatorOptions options evas_profile=balanced

tran tran stop=108n maxstep=120p
save clk rst enable code_3 code_2 code_1 code_0 vout target_dbg settling_metric settled
