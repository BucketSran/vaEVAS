`include "disciplines.vams"
module dac_restore_4bit_clocked(d3, d2, d1, d0, clk, vout);
input d3, d2, d1, d0, clk;
output vout;
electrical d3, d2, d1, d0, clk, vout;
analog begin
    V(vout) <+ 0.0;
end
endmodule
