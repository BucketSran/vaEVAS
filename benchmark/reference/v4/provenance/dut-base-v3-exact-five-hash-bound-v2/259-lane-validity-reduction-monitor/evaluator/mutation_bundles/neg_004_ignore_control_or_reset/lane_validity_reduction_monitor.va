`include "disciplines.vams"

module lane_validity_reduction_monitor(in0, in1, in2, in3, ctrl0, ctrl1, vdd, vss, en, out, flag, metric);
input in0, in1, in2, in3, ctrl0, ctrl1, vdd, vss, en;
output out, flag, metric;
electrical in0, in1, in2, in3, ctrl0, ctrl1, vdd, vss, en, out, flag, metric;

parameter real vth = 0.45;
parameter real vhi = 0.9;
parameter real span_min = 0.62;
parameter real span_max = 1.28;
parameter real tr = 50p;

real span_v, x0, x1, x2, x3, c0, c1, valid_v;
real out_v, flag_v, metric_v;
real core_v, aux_v;

analog function real clip01;
    input x;
    real x;
    begin
        if (x < 0.0) clip01 = 0.0;
        else if (x > 1.0) clip01 = 1.0;
        else clip01 = x;
    end
endfunction

analog function real absr;
    input x;
    real x;
    begin
        absr = (x < 0.0) ? -x : x;
    end
endfunction
analog begin
        span_v = V(vdd, vss);
        valid_v = ((V(en) > vth) && (span_v >= span_min) && (span_v <= span_max)) ? 1.0 : 0.0;
        if (span_v < 0.05) span_v = 0.05;
        x0 = clip01(1.0 - ((V(in0) - V(vss)) / span_v));
        x1 = clip01(1.0 - ((V(in1) - V(vss)) / span_v));
        x2 = clip01(1.0 - ((V(in2) - V(vss)) / span_v));
        x3 = clip01(1.0 - ((V(in3) - V(vss)) / span_v));
        c0 = clip01(V(ctrl0) / vhi);
        c1 = clip01(V(ctrl1) / vhi);
        core_v = (((x0 > 0.50) ? 1.0 : 0.0) + ((x1 > 0.50) ? 1.0 : 0.0) + ((x2 > 0.50) ? 1.0 : 0.0) + ((x3 > 0.50) ? 1.0 : 0.0)) / 4.0;
        aux_v = core_v;
        if (valid_v > 0.5) begin
            out_v = vhi * clip01(core_v);
            flag_v = (((((x0 > 0.50) ? 1.0 : 0.0) + ((x1 > 0.50) ? 1.0 : 0.0) + ((x2 > 0.50) ? 1.0 : 0.0) + ((x3 > 0.50) ? 1.0 : 0.0)) >= 3.0)) ? vhi : 0.0;
            metric_v = vhi * clip01(aux_v);
        end else begin
            out_v = 0.0;
            flag_v = 0.0;
            metric_v = 0.0;
        end
    V(out) <+ out_v;
    V(flag) <+ flag_v;
    V(metric) <+ metric_v;
end
endmodule
