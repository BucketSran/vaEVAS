`include "constants.vams"
`include "disciplines.vams"
`default_transition 30p

// Fixed-gain differential amplifier (no programmable CTRL).
//
//   VOUT_P = vdd/2 + ACTUAL_GAIN * (VIN_P - VIN_N) / 2
//   VOUT_N = vdd/2 - ACTUAL_GAIN * (VIN_P - VIN_N) / 2

module gain_amp_fixed(
    input  electrical VIN_P,
    input  electrical VIN_N,
    output electrical VOUT_P,
    output electrical VOUT_N
);

parameter real vdd         = 0.9;
parameter real ACTUAL_GAIN = 8.64;

real vout_diff;

analog begin
    V(VOUT_P) <+ transition(0.0);
    V(VOUT_N) <+ transition(0.0);
end

endmodule
