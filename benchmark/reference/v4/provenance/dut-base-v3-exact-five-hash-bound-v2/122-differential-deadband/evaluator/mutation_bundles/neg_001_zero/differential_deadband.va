`include "disciplines.vams"

module differential_deadband (sigin_p, sigin_n, sigout);

input sigin_p, sigin_n;
output sigout;
electrical sigin_p, sigin_n, sigout;

analog begin
    V(sigout) <+ 0;
end

endmodule
