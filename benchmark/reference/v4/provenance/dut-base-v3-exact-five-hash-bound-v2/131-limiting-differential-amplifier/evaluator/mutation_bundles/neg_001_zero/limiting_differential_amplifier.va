`include "disciplines.vams"

module limiting_differential_amplifier (sigin_p, sigin_n, sigout);

input sigin_p, sigin_n;
output sigout;
electrical sigin_p, sigin_n, sigout;

analog begin
    V(sigout) <+ 0;
end

endmodule
