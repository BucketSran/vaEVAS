`include "disciplines.vams"

module differential_gain_driver(sigin_p, sigin_n, sigout_p, sigout_n, sigref);
input sigin_p, sigin_n, sigref;
output sigout_p, sigout_n;
electrical sigin_p, sigin_n, sigout_p, sigout_n, sigref;
parameter real gain = 1;

analog begin
    V(sigout_p, sigref) <+ V(sigin_p, sigin_n) * gain / 2;
    V(sigout_n, sigref) <+ -V(sigin_p, sigin_n) * gain / 2;
end

endmodule
