// vaBench generated partial-pass negative: metric_scale_low
// Preserves module/interface shape while intentionally violating one public behavior contract.
`include "disciplines.vams"

module sync_8b_dffs_v2(ck1, ck2, ck3, ck4, ck5, ck6, ck7, ck8, ck9, dl0, dl1, dl2, dl3, dl4, dl5, dl6, dl7, dl8, do0, do1, do2, do3, do4, do5, do6, do7, do8);
input ck1, ck2, ck3, ck4, ck5, ck6, ck7, ck8, ck9;
input dl0, dl1, dl2, dl3, dl4, dl5, dl6, dl7, dl8;
output do0, do1, do2, do3, do4, do5, do6, do7, do8;
electrical ck1, ck2, ck3, ck4, ck5, ck6, ck7, ck8, ck9;
electrical dl0, dl1, dl2, dl3, dl4, dl5, dl6, dl7, dl8;
electrical do0, do1, do2, do3, do4, do5, do6, do7, do8;

parameter real vth = 0.45;
parameter real tt = 20p;
real r0[0:8], r1[0:8], r2[0:8], r3[0:8], r4[0:8], r5[0:8], r6[0:8], r7[0:8], r8[0:8];
genvar i;

analog begin
    @(initial_step) begin
        for (i = 0; i < 9; i = i + 1) begin
            r0[i] = 0; r1[i] = 0; r2[i] = 0; r3[i] = 0; r4[i] = 0;
            r5[i] = 0; r6[i] = 0; r7[i] = 0; r8[i] = 0;
        end
    end
    @(cross(V(ck9) - vth, +1)) r8[8] = V(dl8) > vth;
    @(cross(V(ck8) - vth, +1)) begin r7[8] = r8[8]; r7[7] = V(dl7) > vth; end
    @(cross(V(ck7) - vth, +1)) begin r6[8] = r7[8]; r6[7] = r7[7]; r6[6] = V(dl6) > vth; end
    @(cross(V(ck6) - vth, +1)) begin r5[8] = r6[8]; r5[7] = r6[7]; r5[6] = r6[6]; r5[5] = V(dl5) > vth; end
    @(cross(V(ck5) - vth, +1)) begin r4[8] = r5[8]; r4[7] = r5[7]; r4[6] = r5[6]; r4[5] = r5[5]; r4[4] = V(dl4) > vth; end
    @(cross(V(ck4) - vth, +1)) begin r3[8] = r4[8]; r3[7] = r4[7]; r3[6] = r4[6]; r3[5] = r4[5]; r3[4] = r4[4]; r3[3] = V(dl3) > vth; end
    @(cross(V(ck3) - vth, +1)) begin r2[8] = r3[8]; r2[7] = r3[7]; r2[6] = r3[6]; r2[5] = r3[5]; r2[4] = r3[4]; r2[3] = r3[3]; r2[2] = V(dl2) > vth; end
    @(cross(V(ck2) - vth, +1)) begin r1[8] = r2[8]; r1[7] = r2[7]; r1[6] = r2[6]; r1[5] = r2[5]; r1[4] = r2[4]; r1[3] = r2[3]; r1[2] = r2[2]; r1[1] = V(dl1) > vth; end
    @(cross(V(ck1) - vth, +1)) begin r0[8] = r1[8]; r0[7] = r1[7]; r0[6] = r1[6]; r0[5] = r1[5]; r0[4] = r1[4]; r0[3] = r1[3]; r0[2] = r1[2]; r0[1] = r1[1]; r0[0] = V(dl0) > vth; end

    V(do0) <+ (0.42 * (transition(r0[0], 0, tt, tt)));
    V(do1) <+ (0.42 * (transition(r0[1], 0, tt, tt)));
    V(do2) <+ (0.42 * (transition(r0[2], 0, tt, tt)));
    V(do3) <+ (0.42 * (transition(r0[3], 0, tt, tt)));
    V(do4) <+ (0.42 * (transition(r0[4], 0, tt, tt)));
    V(do5) <+ (0.42 * (transition(r0[5], 0, tt, tt)));
    V(do6) <+ (0.42 * (transition(r0[6], 0, tt, tt)));
    V(do7) <+ (0.42 * (transition(r0[7], 0, tt, tt)));
    V(do8) <+ (0.42 * (transition(r0[8], 0, tt, tt)));
end

endmodule
