`include "disciplines.vams"

        module sync_8b_dffs_v2(ck1, ck2, ck3, ck4, ck5, ck6, ck7, ck8, ck9, dl0, dl1, dl2, dl3, dl4, dl5, dl6, dl7, dl8, do0, do1, do2, do3, do4, do5, do6, do7, do8);
        input ck1, ck2, ck3, ck4, ck5, ck6, ck7, ck8, ck9;
        input dl0, dl1, dl2, dl3, dl4, dl5, dl6, dl7, dl8;
        output do0, do1, do2, do3, do4, do5, do6, do7, do8;
        electrical ck1, ck2, ck3, ck4, ck5, ck6, ck7, ck8, ck9;
        electrical dl0, dl1, dl2, dl3, dl4, dl5, dl6, dl7, dl8;
        electrical do0, do1, do2, do3, do4, do5, do6, do7, do8;

analog begin
    V(do0) <+ 0;
    V(do1) <+ 0;
    V(do2) <+ 0;
    V(do3) <+ 0;
    V(do4) <+ 0;
    V(do5) <+ 0;
    V(do6) <+ 0;
    V(do7) <+ 0;
    V(do8) <+ 0;
end

endmodule
