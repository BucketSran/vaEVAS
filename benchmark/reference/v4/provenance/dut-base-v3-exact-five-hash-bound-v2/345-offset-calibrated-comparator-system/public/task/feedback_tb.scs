simulator lang=spectre
global 0

ahdl_include "./dut/calibrated_comparator_top.va"
ahdl_include "./dut/comparator_core.va"
ahdl_include "./dut/offset_dac.va"
ahdl_include "./dut/calibration_fsm.va"

Vclk (clk 0) vsource type=pulse val0=0 val1=0.9 period=10n width=4n delay=5n rise=100p fall=100p
Vrst (rst 0) vsource type=pwl wave=[0 0.9 2n 0.9 2.1n 0 355n 0]
Vcal_en (cal_en 0) vsource type=pwl wave=[0 0 7n 0 7.1n 0.9 168n 0.9 168.1n 0 183n 0 183.1n 0.9 344n 0.9 344.1n 0 355n 0]
Vcal_ref (cal_ref 0) vsource type=pwl wave=[0 0 7n 0 7.1n 0.9 168n 0.9 168.1n 0 183n 0 183.1n 0 344n 0 344.1n 0 355n 0]
Vvinp (vinp 0) vsource type=pwl wave=[0 0.43 90n 0.43 90.1n 0.52 260n 0.52 260.1n 0.4 355n 0.4]
Vvinn (vinn 0) vsource type=pwl wave=[0 0.45 120n 0.45 120.1n 0.47 300n 0.47 300.1n 0.44 355n 0.44]
XDUT (vinp vinn clk rst cal_en cal_ref decision ready offset_3 offset_2 offset_1 offset_0 threshold_dbg) calibrated_comparator_top

simulatorOptions options evas_profile=balanced

tran tran stop=355n maxstep=100p
save vinp vinn clk rst cal_en cal_ref decision ready offset_3 offset_2 offset_1 offset_0 threshold_dbg
