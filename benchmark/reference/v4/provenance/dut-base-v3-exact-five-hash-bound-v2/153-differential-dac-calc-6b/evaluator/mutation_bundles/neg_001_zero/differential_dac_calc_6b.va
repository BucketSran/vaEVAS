`include "disciplines.vams"

module differential_dac_calc_6b(din0, din1, din2, din3, din4, din5, clks, voutp, voutn);
input din0, din1, din2, din3, din4, din5, clks;
output voutp, voutn;
electrical din0, din1, din2, din3, din4, din5, clks, voutp, voutn;

analog begin
    V(voutp) <+ 0;
    V(voutn) <+ 0;
end

endmodule
