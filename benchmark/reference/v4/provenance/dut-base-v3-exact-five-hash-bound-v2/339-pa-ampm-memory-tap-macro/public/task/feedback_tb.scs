simulator lang=spectre
global 0

ahdl_include "./dut/pa_ampm_memory_tap_macro.va"

Vvin (vin 0) vsource type=pwl wave=[0 0.45 18n 0.45 18.2n 0.66 38n 0.66 38.2n 0.32 58n 0.32 58.2n 0.60 92n 0.60]
Vclk (clk 0) vsource type=pwl wave=[0 0 9n 0 10n 0.9 12n 0.9 12.2n 0 20n 0.9 22n 0.9 22.2n 0 30n 0.9 32n 0.9 32.2n 0 40n 0.9 42n 0.9 42.2n 0 50n 0.9 52n 0.9 52.2n 0 60n 0.9 62n 0.9 62.2n 0 70n 0.9 72n 0.9 72.2n 0 80n 0.9 82n 0.9 82.2n 0 92n 0]
Vrst (rst 0) vsource type=pwl wave=[0 0.9 3n 0.9 3.2n 0 92n 0]
Venable (enable 0) vsource type=pwl wave=[0 0 5n 0 5.2n 0.9 80n 0.9 80.2n 0 92n 0]
Vdrive (drive 0) vsource type=pwl wave=[0 0.45 25n 0.45 25.2n 0.80 55n 0.80 55.2n 0.58 92n 0.58]
XDUT (vin clk rst enable drive vout am_metric pm_metric valid) pa_ampm_memory_tap_macro

simulatorOptions options evas_profile=balanced

tran tran stop=92n maxstep=200p
save vin clk rst enable drive vout am_metric pm_metric valid
