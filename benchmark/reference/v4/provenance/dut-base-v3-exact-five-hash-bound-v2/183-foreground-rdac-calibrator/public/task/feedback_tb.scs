simulator lang=spectre
global 0

ahdl_include "./dut/foreground_rdac_calibrator.va"

Vck (ck 0) vsource type=pwl wave=[0 0 1n 0 1.05n 1 1.45n 1 1.50n 0 3n 0 3.05n 1 3.45n 1 3.50n 0 5n 0 5.05n 1 5.45n 1 5.50n 0 7n 0 7.05n 1 7.45n 1 7.50n 0 9n 0 9.05n 1 9.45n 1 9.50n 0 11n 0 11.05n 1 11.45n 1 11.50n 0 13n 0 13.05n 1 13.45n 1 13.50n 0]
Vd (d 0) vsource type=pwl wave=[0 0 2.8n 0 2.9n 1 4.8n 1 4.9n 0 6.8n 0 6.9n 1 8.8n 1 8.9n 0 10.8n 0 10.9n 1]
Vvrefp (vrefp 0) vsource type=pwl wave=[0 0.78 4n 0.78 4.1n 0.66 10n 0.66 10.1n 0.82]
Vvrefn (vrefn 0) vsource type=pwl wave=[0 0.22 4n 0.22 4.1n 0.31 10n 0.31 10.1n 0.18]
XDUT (ck d vrefp vrefn dc0 dc1 dc2 dc3 dc4 dc5 dc6 cvinp cvinn en enb) foreground_rdac_calibrator

simulatorOptions options evas_profile=balanced

tran tran stop=15n maxstep=20p
save ck cvinn cvinp d dc0 dc1 dc2 dc3 dc4 dc5 dc6 en enb vrefn vrefp
