`include "disciplines.vams"

module deadband_window (sigin, sigout);

input sigin;
output sigout;
electrical sigin, sigout;

parameter real dead_high = 0.1;
parameter real dead_low = -0.1;

real target;

analog begin
    if (V(sigin) < dead_low) begin
        target = V(sigin) - dead_low;
    end else if (V(sigin) > dead_high) begin
        target = V(sigin) - dead_high;
    end else begin
        target = 0.0;
    end
    V(sigout) <+ target;
end

endmodule
