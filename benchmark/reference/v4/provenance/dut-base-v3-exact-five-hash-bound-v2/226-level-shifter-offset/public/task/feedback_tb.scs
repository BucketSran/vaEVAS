simulator lang=spectre
global 0

ahdl_include "./dut/level_shifter_offset.va"

Vsigin (sigin 0) vsource type=pwl wave=[0 -0.3 0.7n -0.3 0.75n 0.2 1.5n 0.2 1.55n 0.9 2.3n 0.9 2.35n -0.1 3.2n -0.1]
XDUT (sigin sigout) level_shifter_offset

simulatorOptions options evas_profile=balanced

tran tran stop=3.0n maxstep=5p
save sigin sigout
