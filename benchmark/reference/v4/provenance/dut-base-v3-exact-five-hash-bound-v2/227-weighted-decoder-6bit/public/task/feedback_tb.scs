simulator lang=spectre
global 0

ahdl_include "./dut/weighted_decoder_6bit.va"

Vd1 (vd1 0) vsource type=pwl wave=[0 0 0.7n 0 0.75n 0.9 1.4n 0.9 1.45n 0 2.1n 0 2.15n 0.9 2.8n 0.9 2.85n 0 3.6n 0]
Vd2 (vd2 0) vsource type=pwl wave=[0 0.9 0.7n 0.9 0.75n 0 1.4n 0 1.45n 0 2.1n 0 2.15n 0.9 2.8n 0.9 2.85n 0.9 3.6n 0.9]
Vd3 (vd3 0) vsource type=pwl wave=[0 0 0.7n 0 0.75n 0.9 1.4n 0.9 1.45n 0.9 2.1n 0.9 2.15n 0 2.8n 0 2.85n 0.9 3.6n 0.9]
Vd4 (vd4 0) vsource type=pwl wave=[0 0.9 0.7n 0.9 0.75n 0 1.4n 0 1.45n 0.9 2.1n 0.9 2.15n 0.9 2.8n 0.9 2.85n 0 3.6n 0]
Vd5 (vd5 0) vsource type=pwl wave=[0 0 0.7n 0 0.75n 0 1.4n 0 1.45n 0.9 2.1n 0.9 2.15n 0 2.8n 0 2.85n 0.9 3.6n 0.9]
Vd6 (vd6 0) vsource type=pwl wave=[0 0.9 0.7n 0.9 0.75n 0 1.4n 0 1.45n 0 2.1n 0 2.15n 0.9 2.8n 0.9 2.85n 0 3.6n 0]
XDUT (vd1 vd2 vd3 vd4 vd5 vd6 vout) weighted_decoder_6bit

simulatorOptions options evas_profile=balanced

tran tran stop=3.4n maxstep=5p
save vd1 vd2 vd3 vd4 vd5 vd6 vout
