`include "disciplines.vams"

        module onehot_progress_encoder(ck, d0, d1, d2, d3, d4, d5, d6, d7, d8, d9, d10, d11, d12, d13, d14, d15, sum);
        input ck;
        output d0, d1, d2, d3, d4, d5, d6, d7, d8, d9, d10, d11, d12, d13, d14, d15, sum;
        electrical ck, d0, d1, d2, d3, d4, d5, d6, d7, d8, d9, d10, d11, d12, d13, d14, d15, sum;

analog begin
    V(d0) <+ 0;
    V(d1) <+ 0;
    V(d2) <+ 0;
    V(d3) <+ 0;
    V(d4) <+ 0;
    V(d5) <+ 0;
    V(d6) <+ 0;
    V(d7) <+ 0;
    V(d8) <+ 0;
    V(d9) <+ 0;
    V(d10) <+ 0;
    V(d11) <+ 0;
    V(d12) <+ 0;
    V(d13) <+ 0;
    V(d14) <+ 0;
    V(d15) <+ 0;
    V(sum) <+ 0;
end

endmodule
