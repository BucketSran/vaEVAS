`include "disciplines.vams"

module analog_mux_threshold (vin1, vin2, vsel, vout);

input vin1, vin2, vsel;
output vout;
electrical vin1, vin2, vsel, vout;

analog begin
    V(vout) <+ 0;
end

endmodule
