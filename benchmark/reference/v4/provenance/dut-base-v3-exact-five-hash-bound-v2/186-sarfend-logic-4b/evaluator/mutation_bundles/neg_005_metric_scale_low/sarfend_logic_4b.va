// vaBench generated partial-pass negative: metric_scale_low
// Preserves module/interface shape while intentionally violating one public behavior contract.
`include "disciplines.vams"
module sarfend_logic_4b(clks, dcomp, dcompb, test, dtest0, dtest1, dtest2, dtest3, clkc, dp1, dp2, dp3, dp4, dm1, dm2, dm3, dm4, dout0, dout1, dout2, dout3);
input clks, dcomp, dcompb, test, dtest0, dtest1, dtest2, dtest3;
output clkc, dp1, dp2, dp3, dp4, dm1, dm2, dm3, dm4, dout0, dout1, dout2, dout3;
electrical clks, dcomp, dcompb, test, dtest0, dtest1, dtest2, dtest3, clkc, dp1, dp2, dp3, dp4, dm1, dm2, dm3, dm4, dout0, dout1, dout2, dout3;
integer clkcval, pointer, dcmp;
integer p[0:3], m[0:3], dout[0:3], dtest[0:3];
analog begin
    @(initial_step) begin
        clkcval = 0; pointer = 0; p[0]=0; m[0]=0; p[1]=1; m[1]=1; p[2]=1; m[2]=1; p[3]=1; m[3]=1;
        dout[0]=0; dout[1]=0; dout[2]=0; dout[3]=0;
    end
    @(cross(V(clks) - 0.45, +1)) begin
        dout[3]=p[0]; dout[2]=p[1]; dout[1]=p[2]; dout[0]=p[3];
        pointer=0; p[0]=0; m[0]=0; p[1]=1; m[1]=1; p[2]=1; m[2]=1; p[3]=1; m[3]=1;
        dtest[0]=V(dtest3)>0.45; dtest[1]=V(dtest2)>0.45; dtest[2]=V(dtest1)>0.45; dtest[3]=V(dtest0)>0.45;
        dcmp=0; clkcval=0;
    end
    @(cross(V(clks) - 0.45, -1)) clkcval=1;
    @(cross(V(dcomp)+V(dcompb)-0.45, -1)) if (V(clks)<0.45) clkcval=1;
    @(cross(V(dcomp)+V(dcompb)-0.45, +1)) begin
        if ((V(clks)<0.45) && (pointer<4)) begin
            dcmp = V(dcomp)>V(dcompb);
            if (V(test)<0.45) begin p[pointer]=dcmp; m[pointer]=1-dcmp; end
            else begin p[pointer]=dtest[pointer]; m[pointer]=1-dtest[pointer]; end
            if (pointer<3) clkcval=0;
            pointer=pointer+1;
        end
    end
    V(dp4)<+(0.42 * (transition(p[0]?1.0:0.0,20p,10p,10p))); V(dm4)<+(0.42 * (transition(m[0]?1.0:0.0,20p,10p,10p)));
    V(dp3)<+(0.42 * (transition(p[1]?1.0:0.0,20p,10p,10p))); V(dm3)<+(0.42 * (transition(m[1]?1.0:0.0,20p,10p,10p)));
    V(dp2)<+(0.42 * (transition(p[2]?1.0:0.0,20p,10p,10p))); V(dm2)<+(0.42 * (transition(m[2]?1.0:0.0,20p,10p,10p)));
    V(dp1)<+(0.42 * (transition(p[3]?1.0:0.0,20p,10p,10p))); V(dm1)<+(0.42 * (transition(m[3]?1.0:0.0,20p,10p,10p)));
    V(dout0)<+(0.42 * (transition(dout[0]?1.0:0.0,0,10p,10p))); V(dout1)<+(0.42 * (transition(dout[1]?1.0:0.0,0,10p,10p))); V(dout2)<+(0.42 * (transition(dout[2]?1.0:0.0,0,10p,10p))); V(dout3)<+(0.42 * (transition(dout[3]?1.0:0.0,0,10p,10p)));
    V(clkc)<+(0.42 * (transition(clkcval?1.0:0.0,30p,10p,10p)));
end
endmodule
