simulator lang=spectre
global 0

ahdl_include "./dut/glitchless_clock_mux_selector.va"

Vclk_a (clk_a 0) vsource type=pulse val0=0 val1=0.9 delay=8n period=8n width=2.4n rise=80p fall=80p
Vclk_b (clk_b 0) vsource type=pulse val0=0 val1=0.9 delay=10n period=8n width=2.4n rise=80p fall=80p
Vsel (sel 0) vsource type=pwl wave=[0 0 8n 0 8.2n 0 18n 0 18.2n 0 28n 0 28.2n 0.9 38n 0.9 38.2n 0.9 48n 0.9 48.2n 0 58n 0 58.2n 0.9 68n 0.9 68.2n 0 78n 0 78.2n 0.9 92n 0.9]
Vrst (rst 0) vsource type=pwl wave=[0 0.9 3n 0.9 3.2n 0 92n 0]
Venable (enable 0) vsource type=pwl wave=[0 0 5n 0 5.2n 0.9 80n 0.9 80.2n 0 92n 0]
XDUT (clk_a clk_b sel rst enable clk_out switch_metric valid) glitchless_clock_mux_selector

simulatorOptions options evas_profile=balanced

tran tran stop=92n maxstep=200p
save clk_a clk_b sel rst enable clk_out switch_metric valid
