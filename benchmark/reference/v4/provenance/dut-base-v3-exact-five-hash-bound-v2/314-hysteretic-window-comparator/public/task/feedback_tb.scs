simulator lang=spectre
global 0

ahdl_include "./dut/hysteretic_window_comparator.va"

Vvin (vin 0) vsource type=pwl wave=[0 0.28 8n 0.28 14n 0.43 23n 0.43 31n 0.50 44n 0.50 44.1n 0.625 47n 0.625 47.1n 0.66 50n 0.66 50.1n 0.50 70n 0.50 70.1n 0.395 75n 0.395 75.1n 0.38 80n 0.38]
Vrst (rst 0) vsource type=pwl wave=[0 0.9 2.1n 0.9 2.2n 0 52n 0 52.1n 0.9 55.5n 0.9 55.6n 0 80n 0]
Venable (enable 0) vsource type=pwl wave=[0 0 5n 0 5.1n 0.9 34n 0.9 34.1n 0 38n 0 38.1n 0.9 80n 0.9]
Vlow_trip (low_trip 0) vsource type=dc dc=0.40
Vhigh_trip (high_trip 0) vsource type=dc dc=0.62
XDUT (vin rst enable low_trip high_trip inside_flag state_metric toggled) hysteretic_window_comparator

simulatorOptions options evas_profile=balanced

tran tran stop=80n maxstep=80p
save vin rst enable low_trip high_trip inside_flag state_metric toggled
