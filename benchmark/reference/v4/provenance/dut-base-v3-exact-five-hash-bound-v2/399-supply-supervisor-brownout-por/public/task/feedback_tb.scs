simulator lang=spectre
global 0

ahdl_include "./dut/supply_supervisor_brownout_por.va"

Vclk (clk 0) vsource type=pulse val0=0 val1=0.9 period=7n width=3.5n delay=1.5n rise=60p fall=60p
Vrst (rst 0) vsource type=pwl wave=[0 0.9 2.5n 0.9 2.6n 0 132n 0]
Ven (enable 0) vsource type=pwl wave=[0 0 3.5n 0 3.6n 0.9 108n 0.9 108.1n 0 116n 0 116.1n 0.9 132n 0.9]
Vsup (vdd_sense 0) vsource type=pwl wave=[0 0.58 9n 0.58 9.1n 0.74 51n 0.74 51.1n 0.66 65n 0.66 65.1n 0.62 76n 0.62 76.1n 0.86 132n 0.86]
XDUT (vdd_sense clk rst enable por_n pgood brownout delay_metric state_metric) supply_supervisor_brownout_por release_cycles=4

simulatorOptions options evas_profile=balanced

tran tran stop=132n maxstep=70p
save vdd_sense clk rst enable por_n pgood brownout delay_metric state_metric
