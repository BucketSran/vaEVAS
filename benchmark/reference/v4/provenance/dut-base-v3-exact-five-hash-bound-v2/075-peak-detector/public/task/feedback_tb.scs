simulator lang=spectre
global 0

ahdl_include "./dut/peak_detector.va"

Vin (vin 0) vsource type=pwl wave=[0 0.1 30n 0.1 40n 0.55 80n 0.55 90n 0.25 130n 0.25 140n 0.7 150.15n 0.7 150.20n 0.88 150.30n 0.88 150.35n 0.7 175n 0.7]
Vrst (rst 0) vsource type=pwl wave=[0 0.9 10n 0.9 11n 0 120n 0 121n 0.9 135n 0.9 136n 0 180n 0]
XDUT (vin rst vout) peak_detector

simulatorOptions options evas_profile=balanced

tran tran stop=180n maxstep=500p
save vin rst vout
