simulator lang=spectre
global 0

ahdl_include "./dut/offset_servo_top.va"
ahdl_include "./dut/offset_sampler.va"
ahdl_include "./dut/trim_dac.va"
ahdl_include "./dut/error_integrator.va"

Vclk (clk 0) vsource type=pulse val0=0 val1=0.9 period=5n width=2.5n delay=1n rise=60p fall=60p
Vrst (rst 0) vsource type=pwl wave=[0 0.9 2.0n 0.9 2.1n 0 96n 0]
Vcal (cal_en 0) vsource type=pwl wave=[0 0 6n 0 6.1n 0.9 66n 0.9 66.1n 0 74n 0 74.1n 0.9 96n 0.9]
Vvinp (vinp 0) vsource type=pwl wave=[0 0.455 8n 0.455 22n 0.465 38n 0.435 56n 0.448 78n 0.462 96n 0.462]
Vvinn (vinn 0) vsource type=pwl wave=[0 0.445 8n 0.445 22n 0.435 38n 0.465 56n 0.452 78n 0.438 96n 0.438]

XDUT (vinp vinn clk rst cal_en corrected_out trim_4 trim_3 trim_2 trim_1 trim_0 error_metric done) offset_servo_top

simulatorOptions options evas_profile=balanced

tran tran stop=96n maxstep=100p
save vinp vinn clk rst cal_en corrected_out trim_4 trim_3 trim_2 trim_1 trim_0 error_metric done
