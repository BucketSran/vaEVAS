simulator lang=spectre
global 0

ahdl_include "./dut/fracn_synth_top.va"
ahdl_include "./dut/accumulator.va"
ahdl_include "./dut/multi_modulus_divider.va"
ahdl_include "./dut/ratio_monitor.va"

Vref (ref_clk 0) vsource type=pulse val0=0 val1=0.9 delay=3n period=18n width=9n rise=50p fall=50p
Vdco (dco_clk 0) vsource type=pulse val0=0 val1=0.9 delay=1.3n period=600p width=300p rise=10p fall=10p
Vrst (rst 0) vsource type=pwl wave=[0 0.9 3n 0.9 3.1n 0 360n 0]
Ven (enable 0) vsource type=pwl wave=[0 0 5n 0 5.1n 0.9 320n 0.9 320.1n 0 332n 0 332.1n 0.9 360n 0.9]
Vf3 (frac_3 0) vsource type=pwl wave=[0 0 220n 0 220.1n 0.9 360n 0.9]
Vf2 (frac_2 0) vsource type=pwl wave=[0 0 105n 0 105.1n 0.9 220n 0.9 220.1n 0 328n 0 328.1n 0.9 360n 0.9]
Vf1 (frac_1 0) vsource type=pwl wave=[0 0 105n 0 105.1n 0.9 360n 0.9]
Vf0 (frac_0 0) vsource type=pwl wave=[0 0 220n 0 220.1n 0.9 360n 0.9]
XDUT (ref_clk dco_clk rst enable frac_3 frac_2 frac_1 frac_0 div_clk div_sel avg_ratio_metric valid) fracn_synth_top

simulatorOptions options evas_profile=balanced

tran tran stop=360n maxstep=100p
save ref_clk dco_clk rst enable frac_3 frac_2 frac_1 frac_0 div_clk div_sel avg_ratio_metric valid
