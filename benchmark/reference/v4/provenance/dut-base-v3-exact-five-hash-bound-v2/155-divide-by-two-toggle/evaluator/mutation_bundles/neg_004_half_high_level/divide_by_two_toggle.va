`include "disciplines.vams"

module divide_by_two_toggle(clkin, clkout);
input clkin;
output clkout;
electrical clkin, clkout;

integer state;

analog begin
    @(initial_step) state = 0;
    @(cross(V(clkin) - 0.5, +1)) state = 1 - state;
    V(clkout) <+ transition(state ? 0.45 : 0.0, 0, 10p, 10p);
end

endmodule
