`include "constants.vams"
`include "disciplines.vams"

module power_good(clk, rst, enable, vfb, vref, pgood);
    input clk, rst, enable, vfb, vref;
    output pgood;
    electrical clk, rst, enable, vfb, vref, pgood;

    parameter real vdd = 0.9;
    parameter real vss = 0.0;
    parameter real vth = 0.45;
    parameter real pgood_tol = 25e-3;
    parameter real tr = 200p from (0:inf);

    integer good_count;
    real pgood_state;
    real err;

    analog begin
        @(initial_step) begin
            good_count = 0;
            pgood_state = vss;
        end

        @(cross(V(clk) - vth, +1)) begin
            err = V(vfb) - V(vref);
            if ((V(rst) > vth) || (V(enable) <= vth)) begin
                good_count = 0;
                pgood_state = vss;
            end else if ((err <= pgood_tol) && (err >= -pgood_tol)) begin
                if (good_count < 3)
                    good_count = good_count + 1;
                if (good_count >= 3)
                    pgood_state = vdd;
            end else begin
                good_count = 0;
                pgood_state = vss;
            end
        end

        V(pgood) <+ transition(pgood_state, 0, tr, tr);
    end
endmodule
