simulator lang=spectre
global 0

ahdl_include "./dut/downconversion_mixer_lo_polarity.va"

Vrst (rst 0) vsource type=pwl wave=[0 0.9 2.5n 0.9 2.6n 0 112n 0]
Ven (enable 0) vsource type=pwl wave=[0 0 3.5n 0 3.6n 0.9 90n 0.9 90.1n 0 98n 0 98.1n 0.9 112n 0.9]
Vloi (lo_i 0) vsource type=pulse val0=0 val1=0.9 period=18n width=9n delay=5n rise=60p fall=60p
Vloq (lo_q 0) vsource type=pulse val0=0 val1=0.9 period=18n width=9n delay=9.5n rise=60p fall=60p
Vrf (rf_in 0) vsource type=pwl wave=[0 0.45 7n 0.45 7.1n 0.82 49n 0.82 49.1n 0.08 77n 0.08 77.1n -0.8 112n -0.8]
XDUT (rf_in lo_i lo_q rst enable i_out q_out lo_i_metric lo_q_metric polarity_ok) downconversion_mixer_lo_polarity conversion_gain=0.5

simulatorOptions options evas_profile=balanced

tran tran stop=112n maxstep=70p
save rf_in lo_i lo_q rst enable i_out q_out lo_i_metric lo_q_metric polarity_ok
