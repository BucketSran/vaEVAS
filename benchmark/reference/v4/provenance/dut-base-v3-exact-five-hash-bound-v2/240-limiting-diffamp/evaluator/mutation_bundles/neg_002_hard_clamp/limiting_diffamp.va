`include "disciplines.vams"
module limiting_diffamp(sigin_p, sigin_n, sigout);
input sigin_p, sigin_n; output sigout; electrical sigin_p, sigin_n, sigout; parameter real gain=4.0;
parameter real limit = 0.75 from (0:inf);
real y;
analog begin y = gain * V(sigin_p,sigin_n); if (y > limit) y = limit; if (y < -limit) y = -limit; V(sigout) <+ y; end
endmodule
