simulator lang=spectre
global 0

ahdl_include "./dut/deserializer_demux_alignment_macro.va"

Vclk (clk 0) vsource type=pwl wave=[0 0 9n 0 10n 0.9 12n 0.9 12.2n 0 20n 0.9 22n 0.9 22.2n 0 30n 0.9 32n 0.9 32.2n 0 40n 0.9 42n 0.9 42.2n 0 50n 0.9 52n 0.9 52.2n 0 60n 0.9 62n 0.9 62.2n 0 70n 0.9 72n 0.9 72.2n 0 80n 0.9 82n 0.9 82.2n 0 92n 0]
Vrst (rst 0) vsource type=pwl wave=[0 0.9 3n 0.9 3.2n 0 92n 0]
Venable (enable 0) vsource type=pwl wave=[0 0 5n 0 5.2n 0.9 82n 0.9 82.2n 0 92n 0]
Vserial_in (serial_in 0) vsource type=pwl wave=[0 0 8n 0 8.2n 0 18n 0 18.2n 0.9 28n 0.9 28.2n 0.9 38n 0.9 38.2n 0 48n 0 48.2n 0.9 58n 0.9 58.2n 0 68n 0 68.2n 0 78n 0 78.2n 0.9 92n 0.9]
Valign_pulse (align_pulse 0) vsource type=pwl wave=[0 0 8n 0 8.2n 0.9 9n 0.9 9.2n 0 35n 0 35.2n 0.9 36n 0.9 36.2n 0 92n 0]
XDUT (clk rst enable serial_in align_pulse out0 out1 out2 out3 phase_metric word_valid) deserializer_demux_alignment_macro

simulatorOptions options evas_profile=balanced

tran tran stop=92n maxstep=200p
save clk rst enable serial_in align_pulse out0 out1 out2 out3 phase_metric word_valid
