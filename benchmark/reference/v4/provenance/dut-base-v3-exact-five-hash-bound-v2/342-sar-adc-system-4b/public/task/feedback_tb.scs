simulator lang=spectre
global 0

ahdl_include "./dut/sar_adc_top.va"
ahdl_include "./dut/sample_hold.va"
ahdl_include "./dut/sar_comparator.va"
ahdl_include "./dut/sar_controller.va"
ahdl_include "./dut/binary_weighted_cdac.va"

Vclk (clk 0) vsource type=pulse val0=0 val1=0.9 period=10n width=4n delay=5n rise=100p fall=100p
Vrst (rst 0) vsource type=pwl wave=[0 0.9 2n 0.9 2.1n 0 215n 0]
Vvin (vin 0) vsource type=pwl wave=[0 0.05 68n 0.05 68.1n 0.43 138n 0.43 138.1n 0.86 215n 0.86]
Vstart (start 0) vsource type=pwl wave=[0 0 7n 0 7.1n 0.9 8n 0.9 8.1n 0 77n 0 77.1n 0.9 78n 0.9 78.1n 0 147n 0 147.1n 0.9 148n 0.9 148.1n 0 215n 0]
XDUT (vin clk rst start code_3 code_2 code_1 code_0 done sample_dbg dac_dbg) sar_adc_top

simulatorOptions options evas_profile=balanced

tran tran stop=215n maxstep=100p
save vin clk rst start code_3 code_2 code_1 code_0 done sample_dbg dac_dbg
