`include "constants.vams"
`include "disciplines.vams"

module sample_hold(vin, clk, rst, sample_en, sample_o, sample_dbg);
input vin, clk, rst, sample_en;
output sample_o, sample_dbg;
electrical vin, clk, rst, sample_en, sample_o, sample_dbg;

parameter real vss = 0.0;
parameter real vth = 0.45;
parameter real tr = 200p;

real held;

analog begin
    @(initial_step) held = vss;

    @(cross(V(rst) - vth, +1)) held = vss;

    @(cross(V(clk) - vth, +1)) begin
        if (V(rst) > vth) begin
            held = vss;
        end else if (V(sample_en) > vth) begin
            held = V(vin);
        end
    end

    V(sample_o) <+ transition(held, 0, tr, tr);
    V(sample_dbg) <+ transition(held, 0, tr, tr);
end
endmodule
