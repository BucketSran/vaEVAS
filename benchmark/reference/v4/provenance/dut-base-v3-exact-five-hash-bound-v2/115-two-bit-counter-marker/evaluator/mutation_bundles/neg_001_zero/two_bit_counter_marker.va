`include "disciplines.vams"

module two_bit_counter_marker (CLKIN, MC);

input CLKIN;
output MC;
electrical CLKIN, MC;

analog begin
    V(MC) <+ 0;
end

endmodule
