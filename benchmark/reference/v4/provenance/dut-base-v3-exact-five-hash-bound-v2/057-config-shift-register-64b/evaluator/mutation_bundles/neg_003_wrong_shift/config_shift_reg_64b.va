`include "constants.vams"
`include "disciplines.vams"

module config_shift_reg_64b(
    input electrical clk,
    input electrical rst_n,
    input electrical serial_in,
    output electrical [63:0] q
);
    parameter real vdd = 0.9;
    parameter real vth = 0.45;
    parameter real tr = 20p;

    integer bit_q[63:0];
    integer j;
    genvar i;

    analog begin
        @(initial_step) begin
            for (j = 0; j < 64; j = j + 1) bit_q[j] = 0;
        end
        @(cross(V(clk) - vth, +1)) begin
            if (V(rst_n) < vth) begin
                for (j = 0; j < 64; j = j + 1) bit_q[j] = 0;
            end else begin
                for (j = 63; j > 0; j = j - 1) bit_q[j] = bit_q[j - 1];
                bit_q[0] = (V(serial_in) > vth) ? 1 : 0;
                for (j = 63; j > 0; j = j - 1) bit_q[j] = bit_q[j - 1];
                bit_q[0] = (V(serial_in) > vth) ? 1 : 0;
            end
        end
        for (i = 0; i < 64; i = i + 1) begin
            V(q[i]) <+ transition((bit_q[i] != 0) ? vdd : 0.0, 0, tr, tr);
        end
    end
endmodule
