`include "disciplines.vams"

        module tdc_ideal_edge_delta(inp, inn, samp, vout);
        input inp, inn, samp;
        output vout;
        electrical inp, inn, samp, vout;

analog begin
    V(vout) <+ 0;
end

endmodule
