`include "disciplines.vams"
module voltage_controlled_gain_amplifier(vin_p, vin_n, vctrl_p, vctrl_n, vout);
input vin_p, vin_n, vctrl_p, vctrl_n; output vout; electrical vin_p, vin_n, vctrl_p, vctrl_n, vout;
analog begin V(vout)<+1.5*V(vctrl_p,vctrl_n)*(V(vin_p,vin_n)-0.05)+0.5; end
endmodule
