simulator lang=spectre
global 0

ahdl_include "./dut/pfd_tdomain_reset_window.va"

Vdd (vdd 0) vsource dc=1
Vgnd (gnd 0) vsource dc=0
Vin1 (in1 0) vsource type=pwl wave=[0 0 0.9n 0 0.92n 1 1.2n 1 1.22n 0 3.0n 0 3.02n 1 3.3n 1 3.32n 0 5n 0]
Vin2 (in2 0) vsource type=pwl wave=[0 0 1.45n 0 1.47n 1 1.75n 1 1.77n 0 2.55n 0 2.57n 1 2.85n 1 2.87n 0 5n 0]
XDUT (in1 in2 up dn vdd gnd) pfd_tdomain_reset_window

simulatorOptions options evas_profile=balanced

tran tran stop=3.8n maxstep=5p
save dn in1 in2 up vdd gnd
