simulator lang=spectre
global 0

ahdl_include "./dut/current_limited_regulator_macro.va"

Vrst (rst 0) vsource type=pwl wave=[0 0.9 4n 0.9 4.2n 0 175n 0 175.2n 0.9 188n 0.9 188.2n 0]
Ven (enable 0) vsource type=pwl wave=[0 0 5n 0 5.2n 0.9 145n 0.9 145.2n 0 160n 0 160.2n 0.9 230n 0.9]
Vvin (vin 0) vsource type=pwl wave=[0 1.05 50n 1.05 50.2n 0.76 95n 0.76 95.2n 0.62 135n 0.62 135.2n 1.00 230n 1.00]
Vload (load_demand 0) vsource type=pwl wave=[0 0.22 80n 0.22 80.2n 0.72 120n 0.72 120.2n 0.91 205n 0.91 205.2n 0.40 230n 0.40]
XDUT (vin load_demand enable rst vout limit_metric regulation_ok) current_limited_regulator_macro vref=0.75 dropout=0.08 demand_limit=0.65

simulatorOptions options evas_profile=balanced

tran tran stop=230n maxstep=100p
save vin load_demand enable rst vout limit_metric regulation_ok
