simulator lang=spectre
global 0

ahdl_include "./dut/vga_cal_loop_top.va"
ahdl_include "./dut/peak_detector.va"
ahdl_include "./dut/gain_controller.va"
ahdl_include "./dut/vga_model.va"
ahdl_include "./dut/lock_detector.va"

Vclk (clk 0) vsource type=pulse val0=0 val1=0.9 period=5n width=2n delay=2.5n rise=100p fall=100p
Vrst (rst 0) vsource type=pwl wave=[0 0.9 1n 0.9 1.1n 0 225n 0]
Vstart (start 0) vsource type=pwl wave=[0 0 3n 0 3.1n 0.9 225n 0.9]
Vvin (vin 0) vsource type=pwl wave=[0 0.1 70n 0.1 70.1n 0.75 150n 0.75 150.1n 0.4 190n 0.4 190.1n -0.4 225n -0.4]
Vtarget (target 0) vsource type=pwl wave=[0 0.4 225n 0.4]
XDUT (vin target clk rst start vout gain_3 gain_2 gain_1 gain_0 locked peak_metric) vga_cal_loop_top

simulatorOptions options evas_profile=balanced

tran tran stop=225n maxstep=100p
save vin target clk rst start vout gain_3 gain_2 gain_1 gain_0 locked peak_metric
