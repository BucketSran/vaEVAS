`include "disciplines.vams"
module accum3_pulse(clk, out);
input clk;
output out;
electrical clk, out;
analog begin
    V(out) <+ 0.0;
end
endmodule
