simulator lang=spectre
global 0

ahdl_include "./dut/dac_restore_10bit_offset.va"

Vclk (clk 0) vsource type=pwl wave=[0 0 1n 0 1.05n 0.9 1.50n 0.9 1.55n 0 11n 0 11.05n 0.9 11.50n 0.9 11.55n 0 21n 0 21.05n 0.9 21.50n 0.9 21.55n 0 31n 0 31.05n 0.9 31.50n 0.9 31.55n 0 42n 0 42.05n 0.9 42.50n 0.9 42.55n 0]
VD1 (D1 0) vsource type=pwl wave=[0 0 27.95n 0 28n 0.9 37.95n 0.9 38n 0]
VD2 (D2 0) vsource type=pwl wave=[0 0 7.95n 0 8n 0.9 37.95n 0.9 38n 0]
VD3 (D3 0) vsource type=pwl wave=[0 0 17.95n 0 18n 0.9 37.95n 0.9 38n 0]
VD4 (D4 0) vsource type=pwl wave=[0 0 7.95n 0 8n 0.9 17.95n 0.9 18n 0 27.95n 0 28n 0.9 37.95n 0.9 38n 0]
VD5 (D5 0) vsource type=pwl wave=[0 0 27.95n 0 28n 0.9 37.95n 0.9 38n 0]
VD6 (D6 0) vsource type=pwl wave=[0 0 7.95n 0 8n 0.9 37.95n 0.9 38n 0]
VD7 (D7 0) vsource type=pwl wave=[0 0 37.95n 0 38n 0.9]
VD8 (D8 0) vsource type=pwl wave=[0 0 7.95n 0 8n 0.9 17.95n 0.9 18n 0 27.95n 0 28n 0.9 37.95n 0.9 38n 0]
VD9 (D9 0) vsource type=pwl wave=[0 0 17.95n 0 18n 0.9 37.95n 0.9 38n 0]
VD10 (D10 0) vsource type=pwl wave=[0 0 7.95n 0 8n 0.9 37.95n 0.9 38n 0]
VD0 (D0 0) vsource type=pwl wave=[0 0 3.95n 0 4n 0.9 5.95n 0.9 6n 0 7.95n 0 8n 0.9 17.95n 0.9 18n 0 27.95n 0 28n 0.9 37.95n 0.9 38n 0]
XDUT (D1 D2 D3 D4 D5 D6 D7 D8 D9 D10 D0 clk vout) dac_restore_10bit_offset

simulatorOptions options evas_profile=balanced

tran tran stop=46n maxstep=20p
save clk D0 D1 D2 D3 D4 D5 D6 D7 D8 D9 D10 vout
