`include "disciplines.vams"
module deadband_diffamp(sigin_p, sigin_n, sigout);
input sigin_p, sigin_n;
output sigout;
electrical sigin_p, sigin_n, sigout;
parameter real sigin_dead_low = -0.1;
parameter real sigin_dead_high = 0.1;
parameter real sigout_leak = 0.02;
parameter real gain_low = 2.0;
parameter real gain_high = 3.0;
real diff;
real target;
analog begin
    diff = V(sigin_p, sigin_n);
    if (diff < sigin_dead_low)
        target = gain_low * (diff - sigin_dead_low) + sigout_leak;
    else if (diff > sigin_dead_high)
        target = gain_high * (diff - sigin_dead_high) + sigout_leak;
    else
        target = sigout_leak;
    V(sigout) <+ target;
end
endmodule
