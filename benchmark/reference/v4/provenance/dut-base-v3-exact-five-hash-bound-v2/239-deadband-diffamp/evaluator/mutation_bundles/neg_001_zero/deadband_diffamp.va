`include "disciplines.vams"
module deadband_diffamp(sigin_p, sigin_n, sigout);
input sigin_p, sigin_n;
output sigout;
electrical sigin_p, sigin_n, sigout;
analog begin
    V(sigout) <+ 0.0;
end
endmodule
