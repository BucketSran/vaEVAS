simulator lang=spectre
global 0

ahdl_include "./dut/multiphase_clock_generator_4ph.va"

Vvss (vss 0) vsource dc=0.2
XDUT (vss clk0 clk90 clk180 clk270) multiphase_clock_generator_4ph

simulatorOptions options evas_profile=balanced

tran tran stop=100n maxstep=50p
save vss clk0 clk90 clk180 clk270
