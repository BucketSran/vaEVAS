`include "disciplines.vams"

module ideal_adc_4bit_quantizer(vclk, vip, vin, digital);
input vclk, vip, vin;
output digital;
electrical vclk, vip, vin, digital;

analog begin
    V(digital) <+ 0;
end

endmodule
