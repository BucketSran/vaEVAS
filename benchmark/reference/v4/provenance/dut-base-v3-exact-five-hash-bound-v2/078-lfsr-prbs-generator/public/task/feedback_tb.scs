simulator lang=spectre
global 0

ahdl_include "./dut/prbs7_ref.va"

Vclk   (clk 0)    vsource type=pulse val0=0 val1=0.9 period=1n delay=0.1n rise=20p fall=20p width=0.5n
Vrst_n (rst_n 0)  vsource type=pulse val0=0 val1=0.9 period=300n delay=2n rise=20p fall=20p width=298n
Ven    (en 0)     vsource type=pwl wave=[0 0.9 35n 0.9 35.1n 0 50n 0 50.1n 0.9 120n 0.9]
XDUT (clk rst_n en serial_out state_0 state_1 state_2 state_3 state_4 state_5 state_6) prbs7_ref

simulatorOptions options evas_profile=balanced

tran tran stop=120n maxstep=50p
save clk rst_n en serial_out state_0 state_1 state_2 state_3 state_4 state_5 state_6
