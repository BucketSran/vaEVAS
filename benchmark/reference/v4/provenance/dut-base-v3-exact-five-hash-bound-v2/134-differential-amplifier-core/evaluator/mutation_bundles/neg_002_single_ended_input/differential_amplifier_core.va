`include "disciplines.vams"
module differential_amplifier_core(sigin_p, sigin_n, sigout);
input sigin_p, sigin_n; output sigout; electrical sigin_p, sigin_n, sigout;
analog begin V(sigout)<+2.0*(V(sigin_p)-0.05); end
endmodule
