simulator lang=spectre
global 0

ahdl_include "./dut/pam4_slicer_gray_decoder.va"

Vclk (clk 0) vsource type=pulse val0=0 val1=0.9 period=10n width=5n delay=1.5n rise=60p fall=60p
Vrst (rst 0) vsource type=pwl wave=[0 0.9 2.5n 0.9 2.6n 0 112n 0]
Ven (enable 0) vsource type=pwl wave=[0 0 3.2n 0 3.3n 0.9 88n 0.9 88.1n 0 96n 0 96.1n 0.9 112n 0.9]
Vvin (vin 0) vsource type=pwl wave=[0 0.224 8n 0.224 8.1n 0.226 18n 0.226 18.1n 0.449 28n 0.449 28.1n 0.451 38n 0.451 38.1n 0.674 48n 0.674 48.1n 0.676 58n 0.676 58.1n 0.05 68n 0.05 68.1n 0.85 112n 0.85]
XDUT (vin clk rst enable bit_msb bit_lsb level_metric valid) pam4_slicer_gray_decoder

simulatorOptions options evas_profile=balanced

tran tran stop=112n maxstep=80p
save vin clk rst enable bit_msb bit_lsb level_metric valid
