`include "disciplines.vams"
module samplehold_rising_edge(control, vin, vout);
input control, vin;
output vout;
electrical control, vin, vout;
parameter real thresh = 2.5;
parameter real tdel = 20p;
parameter real tr = 20p;
real hold;
analog begin
    V(vout) <+ V(vin);
end
endmodule
