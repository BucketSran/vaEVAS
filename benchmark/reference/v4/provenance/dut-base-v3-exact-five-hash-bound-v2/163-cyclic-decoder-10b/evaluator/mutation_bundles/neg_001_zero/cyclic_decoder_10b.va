`include "disciplines.vams"

module cyclic_decoder_10b(dp, dn, ready, clks, dout);
input dp, dn, ready, clks;
output dout;
electrical dp, dn, ready, clks, dout;

analog begin
    V(dout) <+ 0;
end

endmodule
