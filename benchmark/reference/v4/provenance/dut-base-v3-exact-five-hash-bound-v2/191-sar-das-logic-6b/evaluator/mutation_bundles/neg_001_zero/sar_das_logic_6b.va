`include "disciplines.vams"
        module sar_das_logic_6b(clk_sampling, clk_sar, vcomp, d1, d2, d3, d4, d5, d6, db1, db2, db3, db4, db5, db6, co, cob);
        input clk_sampling, clk_sar, vcomp;
        output d1, d2, d3, d4, d5, d6, db1, db2, db3, db4, db5, db6, co, cob;
        electrical clk_sampling, clk_sar, vcomp, d1, d2, d3, d4, d5, d6, db1, db2, db3, db4, db5, db6, co, cob;

analog begin
    V(d1) <+ 0;
    V(d2) <+ 0;
    V(d3) <+ 0;
    V(d4) <+ 0;
    V(d5) <+ 0;
    V(d6) <+ 0;
    V(db1) <+ 0;
    V(db2) <+ 0;
    V(db3) <+ 0;
    V(db4) <+ 0;
    V(db5) <+ 0;
    V(db6) <+ 0;
    V(co) <+ 0;
    V(cob) <+ 0;
end
endmodule
