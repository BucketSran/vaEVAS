`include "disciplines.vams"
module pfd_timer_reset(a, b, ub, d);
input a, b;
output ub, d;
electrical a, b, ub, d;
parameter real vth = 0.45;
parameter real vh = 0.9;
parameter real reset_delay = 100p from [0:inf);
parameter real tr = 10p from [0:inf);
integer up_state, down_state;
real trst;
analog begin
    @(initial_step) begin
        up_state = 0;
        down_state = 0;
        trst = -1.0;
    end
    @(cross(V(a) - vth, +1)) begin
        up_state = 1;
        if (down_state == 1) trst = $abstime + reset_delay;
    end
    @(cross(V(b) - vth, +1)) begin
        down_state = 1;
        if (up_state == 1) trst = $abstime + reset_delay;
    end
    @(timer(trst)) begin
        up_state = 0;
        down_state = 0;
        trst = -1.0;
    end
    V(ub) <+ (up_state ? 0.0 : vh);
    V(d) <+ (down_state ? vh : 0.0);
end
endmodule
