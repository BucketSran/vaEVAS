`include "disciplines.vams"
module lt_readout_sar4(d0, d1, d2, d3, vout, gnd);
input d0, d1, d2, d3, gnd;
output vout;
electrical d0, d1, d2, d3, vout, gnd;
analog begin
    V(vout) <+ 0.0;
end
endmodule
