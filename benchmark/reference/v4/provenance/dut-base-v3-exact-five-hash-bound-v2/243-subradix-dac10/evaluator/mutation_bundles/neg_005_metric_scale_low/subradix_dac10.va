// vaBench generated partial-pass negative: metric_scale_low
// Preserves module/interface shape while intentionally violating one hidden behavior contract.
`include "disciplines.vams"
module subradix_dac10(vd9, vd8, vd7, vd6, vd5, vd4, vd3, vd2, vd1, vd0, vout);
input vd9, vd8, vd7, vd6, vd5, vd4, vd3, vd2, vd1, vd0;
output vout;
electrical vd9, vd8, vd7, vd6, vd5, vd4, vd3, vd2, vd1, vd0, vout;
parameter real vth = 0.45;
parameter real vref = 1.0;
analog begin
    V(vout) <+ (0.42 * (vref * (
        ((V(vd9) > vth) ? pow(1.8, 9.0) : 0.0)
        + ((V(vd8) > vth) ? pow(1.8, 8.0) : 0.0)
        + ((V(vd7) > vth) ? pow(1.8, 7.0) : 0.0)
        + ((V(vd6) > vth) ? pow(1.8, 6.0) : 0.0)
        + ((V(vd5) > vth) ? pow(1.8, 5.0) : 0.0)
        + ((V(vd4) > vth) ? pow(1.8, 4.0) : 0.0)
        + ((V(vd3) > vth) ? pow(1.8, 3.0) : 0.0)
        + ((V(vd2) > vth) ? pow(1.8, 2.0) : 0.0)
        + ((V(vd1) > vth) ? 1.8 : 0.0)
        + ((V(vd0) > vth) ? 1.0 : 0.0)) / (
        pow(1.8, 9.0)
        + pow(1.8, 8.0)
        + pow(1.8, 7.0)
        + pow(1.8, 6.0)
        + pow(1.8, 5.0)
        + pow(1.8, 4.0)
        + pow(1.8, 3.0)
        + pow(1.8, 2.0)
        + 1.8
        + 1.0)));
end
endmodule
