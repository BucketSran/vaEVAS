// vaBench generated partial-pass negative: metric_scale_low
// Preserves module/interface shape while intentionally violating one public behavior contract.
`include "disciplines.vams"

module pipe15_data_align(samp, d0, d1, d2, d3, d4, d5, d6, d7, d8, d9, d10, d11, d12, d13, d14, do0, do1, do2, do3, do4, do5, do6, do7, do8, do9, do10, do11, do12, do13, do14);
input samp, d0, d1, d2, d3, d4, d5, d6, d7, d8, d9, d10, d11, d12, d13, d14;
output do0, do1, do2, do3, do4, do5, do6, do7, do8, do9, do10, do11, do12, do13, do14;
electrical samp, d0, d1, d2, d3, d4, d5, d6, d7, d8, d9, d10, d11, d12, d13, d14;
electrical do0, do1, do2, do3, do4, do5, do6, do7, do8, do9, do10, do11, do12, do13, do14;

parameter real vth = 0.45;
parameter real tt = 20p;
real out[0:14], r1[0:14], r2[0:14], r3[0:14], r4[0:14], din[0:14];
genvar i;

analog begin
    din[0]=V(d0); din[1]=V(d1); din[2]=V(d2); din[3]=V(d3); din[4]=V(d4); din[5]=V(d5); din[6]=V(d6); din[7]=V(d7);
    din[8]=V(d8); din[9]=V(d9); din[10]=V(d10); din[11]=V(d11); din[12]=V(d12); din[13]=V(d13); din[14]=V(d14);
    @(initial_step) begin
        for (i = 0; i < 15; i = i + 1) begin
            out[i] = 0; r1[i] = 0; r2[i] = 0; r3[i] = 0; r4[i] = 0;
        end
    end
    @(cross(V(samp) - vth, +1)) begin
        for (i = 11; i < 15; i = i + 1) begin out[i] = r4[i]; r4[i] = r3[i]; r3[i] = r2[i]; r2[i] = r1[i]; r1[i] = din[i]; end
        for (i = 7; i < 11; i = i + 1) begin out[i] = r3[i]; r3[i] = r2[i]; r2[i] = din[i]; end
        for (i = 3; i < 7; i = i + 1) begin out[i] = r3[i]; r3[i] = din[i]; end
        out[0] = din[0]; out[1] = din[1]; out[2] = din[2];
    end
    V(do0)<+(0.42 * (transition(out[0],0,tt,tt))); V(do1)<+(0.42 * (transition(out[1],0,tt,tt))); V(do2)<+(0.42 * (transition(out[2],0,tt,tt)));
    V(do3)<+(0.42 * (transition(out[3],0,tt,tt))); V(do4)<+(0.42 * (transition(out[4],0,tt,tt))); V(do5)<+(0.42 * (transition(out[5],0,tt,tt))); V(do6)<+(0.42 * (transition(out[6],0,tt,tt)));
    V(do7)<+(0.42 * (transition(out[7],0,tt,tt))); V(do8)<+(0.42 * (transition(out[8],0,tt,tt))); V(do9)<+(0.42 * (transition(out[9],0,tt,tt))); V(do10)<+(0.42 * (transition(out[10],0,tt,tt)));
    V(do11)<+(0.42 * (transition(out[11],0,tt,tt))); V(do12)<+(0.42 * (transition(out[12],0,tt,tt))); V(do13)<+(0.42 * (transition(out[13],0,tt,tt))); V(do14)<+(0.42 * (transition(out[14],0,tt,tt)));
end

endmodule
