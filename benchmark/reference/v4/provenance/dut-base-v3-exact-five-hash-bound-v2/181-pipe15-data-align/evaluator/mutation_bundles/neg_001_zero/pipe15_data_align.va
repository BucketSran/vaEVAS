`include "disciplines.vams"

        module pipe15_data_align(samp, d0, d1, d2, d3, d4, d5, d6, d7, d8, d9, d10, d11, d12, d13, d14, do0, do1, do2, do3, do4, do5, do6, do7, do8, do9, do10, do11, do12, do13, do14);
        input samp, d0, d1, d2, d3, d4, d5, d6, d7, d8, d9, d10, d11, d12, d13, d14;
        output do0, do1, do2, do3, do4, do5, do6, do7, do8, do9, do10, do11, do12, do13, do14;
        electrical samp, d0, d1, d2, d3, d4, d5, d6, d7, d8, d9, d10, d11, d12, d13, d14;
        electrical do0, do1, do2, do3, do4, do5, do6, do7, do8, do9, do10, do11, do12, do13, do14;

analog begin
    V(do0) <+ 0;
    V(do1) <+ 0;
    V(do2) <+ 0;
    V(do3) <+ 0;
    V(do4) <+ 0;
    V(do5) <+ 0;
    V(do6) <+ 0;
    V(do7) <+ 0;
    V(do8) <+ 0;
    V(do9) <+ 0;
    V(do10) <+ 0;
    V(do11) <+ 0;
    V(do12) <+ 0;
    V(do13) <+ 0;
    V(do14) <+ 0;
end

endmodule
