`include "disciplines.vams"
        module l2_cdac_4b_switch(din1, din2, din3, din4, rdy, aout);
        input din1, din2, din3, din4, rdy;
        output aout;
        electrical din1, din2, din3, din4, rdy, aout;

analog begin
    V(aout) <+ 0;
end
endmodule
