simulator lang=spectre
global 0

ahdl_include "./dut/sar_logic_4b_self_timed.va"

Vdd (vdd 0) vsource dc=1
Vgnd (gnd 0) vsource dc=0
Vrst (rst 0) vsource type=pulse val0=0 val1=1 delay=0.05n period=20n width=0.25n rise=20p fall=20p
Vclkc (clkc 0) vsource type=pulse val0=0 val1=1 delay=0.8n period=20n width=0.25n rise=20p fall=20p
Vp (dcmpp 0) vsource type=pwl wave=[0 0 1.25n 0 1.27n 1 1.55n 1 1.57n 0 2.65n 0 2.67n 1 2.95n 1 2.97n 0 6n 0]
Vn (dcmpn 0) vsource type=pwl wave=[0 0 1.95n 0 1.97n 1 2.25n 1 2.27n 0 3.35n 0 3.37n 1 3.65n 1 3.67n 0 6n 0]
XDUT (vdd gnd clkc rst dcmpp dcmpn cmpck dout1 dout2 dout3 dout4 dbotp1 dbotp2 dbotp3 dbotn1 dbotn2 dbotn3) sar_logic_4b_self_timed

simulatorOptions options evas_profile=balanced

tran tran stop=5n maxstep=10p
save clkc cmpck dbotn1 dbotn2 dbotn3 dbotp1 dbotp2 dbotp3 dcmpn dcmpp dout1 dout2 dout3 dout4 rst vdd gnd
