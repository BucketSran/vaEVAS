simulator lang=spectre
global 0

ahdl_include "./dut/window_comparator_ref.va"

V_VDD (VDD 0) vsource dc=0.9
V_VSS (VSS 0) vsource dc=0
V_vin (vin 0) vsource type=pwl wave=[0 0 2.5n 0.9 5n 0]
XDUT (VDD VSS vin out) window_comparator_ref

simulatorOptions options evas_profile=balanced

tran tran stop=5n maxstep=20p errpreset=conservative
save VDD VSS vin out
