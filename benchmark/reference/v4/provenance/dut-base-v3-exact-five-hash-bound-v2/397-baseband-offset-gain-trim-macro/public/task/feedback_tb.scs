simulator lang=spectre
global 0

ahdl_include "./dut/baseband_offset_gain_trim_macro.va"

Vclk (clk 0) vsource type=pulse val0=0 val1=0.9 period=5n width=2.5n delay=1.2n rise=45p fall=45p
Vrst (rst 0) vsource type=pwl wave=[0 0.9 1.7n 0.9 1.8n 0 86n 0]
Ven (enable 0) vsource type=pwl wave=[0 0 4n 0 4.1n 0.9 55n 0.9 55.1n 0 64n 0 64.1n 0.9 86n 0.9]
Vvin (vin 0) vsource type=pwl wave=[0 0.62 7n 0.62 7.1n 0.22 18n 0.22 18.1n 0.76 32n 0.76 32.1n 0.18 48n 0.18 48.1n 0.84 86n 0.84]
Vg0 (gain_0 0) vsource type=pwl wave=[0 0.9 16n 0.9 16.1n 0 40n 0 40.1n 0.9 68n 0.9 68.1n 0 86n 0]
Vg1 (gain_1 0) vsource type=pwl wave=[0 0 24n 0 24.1n 0.9 50n 0.9 50.1n 0 86n 0]
Vg2 (gain_2 0) vsource type=pwl wave=[0 0 36n 0 36.1n 0.9 86n 0.9]
Vo0 (offset_0 0) vsource type=pwl wave=[0 0 20n 0 20.1n 0.9 44n 0.9 44.1n 0 70n 0 70.1n 0.9 86n 0.9]
Vo1 (offset_1 0) vsource type=pwl wave=[0 0.9 28n 0.9 28.1n 0 58n 0 58.1n 0.9 86n 0.9]
Vo2 (offset_2 0) vsource type=pwl wave=[0 0 46n 0 46.1n 0.9 86n 0.9]
XDUT (vin clk rst enable gain_2 gain_1 gain_0 offset_2 offset_1 offset_0 vout residual_metric valid) baseband_offset_gain_trim_macro

simulatorOptions options evas_profile=balanced

tran tran stop=86n maxstep=90p
save vin clk rst enable gain_2 gain_1 gain_0 offset_2 offset_1 offset_0 vout residual_metric valid
