simulator lang=spectre
global 0

ahdl_include "./dut/quad_corr_top.va"
ahdl_include "./dut/gain_trim.va"
ahdl_include "./dut/skew_estimator.va"
ahdl_include "./dut/corrector.va"

Vi (i_in 0) vsource type=pwl wave=[0 0.64 60n 0.64 60.1n 0.62 120n 0.62 120.1n 0.51 178n 0.51]
Vq (q_in 0) vsource type=pwl wave=[0 0.49 60n 0.49 60.1n 0.55 120n 0.55 120.1n 0.55 178n 0.55]
Vclk (clk 0) vsource type=pulse val0=0 val1=0.9 delay=5n period=9n width=4.5n rise=50p fall=50p
Vrst (rst 0) vsource type=pwl wave=[0 0.9 1.8n 0.9 1.9n 0 151n 0 151.1n 0.9 157n 0.9 157.1n 0 178n 0]
Vcal (cal_en 0) vsource type=pwl wave=[0 0 2.5n 0 2.6n 0.9 116n 0.9 116.1n 0 134n 0 134.1n 0.9 178n 0.9]
XDUT (i_in q_in clk rst cal_en i_out q_out gain_code_3 gain_code_2 gain_code_1 gain_code_0 phase_code_3 phase_code_2 phase_code_1 phase_code_0 error_metric locked) quad_corr_top

simulatorOptions options evas_profile=balanced

tran tran stop=178n maxstep=100p
save i_in q_in clk rst cal_en i_out q_out gain_code_3 gain_code_2 gain_code_1 gain_code_0 phase_code_3 phase_code_2 phase_code_1 phase_code_0 error_metric locked
