`include "disciplines.vams"

module ref_flash_8level_decoder(vin, dt0, dt1, dt2, dt3, dt4, dt5, dt6, dt7, clks, dout, vres);
input vin, dt0, dt1, dt2, dt3, dt4, dt5, dt6, dt7, clks;
output dout, vres;
electrical vin, dt0, dt1, dt2, dt3, dt4, dt5, dt6, dt7, clks, dout, vres;
//

analog begin
    V(dout) <+ 0;
    V(vres) <+ 0;
end

endmodule
