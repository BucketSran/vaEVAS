simulator lang=spectre
global 0

ahdl_include "./dut/ref_flash_8level_decoder.va"

Vclks (clks 0) vsource type=pwl wave=[0 0 1n 0 1.05n 0.9 1.50n 0.9 1.55n 0 6n 0 6.05n 0.9 6.50n 0.9 6.55n 0 11n 0 11.05n 0.9 11.50n 0.9 11.55n 0 16n 0 16.05n 0.9 16.50n 0.9 16.55n 0 21n 0 21.05n 0.9 21.50n 0.9 21.55n 0 26n 0 26.05n 0.9 26.50n 0.9 26.55n 0 31n 0 31.05n 0.9 31.50n 0.9 31.55n 0 36n 0 36.05n 0.9 36.50n 0.9 36.55n 0]
Vvin (vin 0) vsource type=pwl wave=[0 0.10 5.80n 0.10 5.85n 0.20 10.80n 0.20 10.85n -0.10 15.80n -0.10 15.85n 0.30 20.80n 0.30 20.85n 0.00 25.80n 0.00 25.85n 0.15 30.80n 0.15 30.85n -0.05 35.80n -0.05 35.85n 0.25]
Vdt0 (dt0 0) vsource type=pwl wave=[0 0 0.80n 0 0.85n 0.9 1.50n 0.9 1.55n 0]
Vdt1 (dt1 0) vsource type=pwl wave=[0 0 5.80n 0 5.85n 0.9 6.50n 0.9 6.55n 0]
Vdt2 (dt2 0) vsource type=pwl wave=[0 0 10.80n 0 10.85n 0.9 11.50n 0.9 11.55n 0]
Vdt3 (dt3 0) vsource type=pwl wave=[0 0 15.80n 0 15.85n 0.9 16.50n 0.9 16.55n 0]
Vdt4 (dt4 0) vsource type=pwl wave=[0 0 20.80n 0 20.85n 0.9 21.50n 0.9 21.55n 0]
Vdt5 (dt5 0) vsource type=pwl wave=[0 0 25.80n 0 25.85n 0.9 26.50n 0.9 26.55n 0]
Vdt6 (dt6 0) vsource type=pwl wave=[0 0 30.80n 0 30.85n 0.9 31.50n 0.9 31.55n 0]
Vdt7 (dt7 0) vsource type=pwl wave=[0 0 35.80n 0 35.85n 0.9 36.50n 0.9 36.55n 0]
XDUT (vin dt0 dt1 dt2 dt3 dt4 dt5 dt6 dt7 clks dout vres) ref_flash_8level_decoder

simulatorOptions options evas_profile=balanced

tran tran stop=42n maxstep=20p
save clks dout dt0 dt1 dt2 dt3 dt4 dt5 dt6 dt7 vin vres
