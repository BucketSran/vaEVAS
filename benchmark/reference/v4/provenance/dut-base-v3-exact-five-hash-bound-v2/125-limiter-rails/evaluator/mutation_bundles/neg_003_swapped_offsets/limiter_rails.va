`include "disciplines.vams"
module limiter_rails (vdd, vss, vin, vmax, vmin, vout);
input vdd, vss, vin, vmax, vmin; output vout; electrical vdd, vss, vin, vmax, vmin, vout;
analog begin
    if (V(vin)>V(vdd)-V(vmin)) V(vout)<+V(vdd)-V(vmin);
    else if (V(vin)<V(vss)+V(vmax)) V(vout)<+V(vss)+V(vmax);
    else V(vout)<+V(vin);
end
endmodule
