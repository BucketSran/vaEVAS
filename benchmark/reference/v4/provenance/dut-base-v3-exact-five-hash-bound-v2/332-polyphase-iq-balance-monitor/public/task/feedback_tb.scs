simulator lang=spectre
global 0

ahdl_include "./dut/polyphase_iq_balance_monitor_top.va"
ahdl_include "./dut/iq_normalizer.va"
ahdl_include "./dut/balance_metric_core.va"

Vi_in (i_in 0) vsource type=pwl wave=[0 0.180 9n 0.180 15n 0.680 28n 0.680 34n 0.440 48n 0.440 80n 0.285]
Vq_in (q_in 0) vsource type=pwl wave=[0 0.270 9n 0.270 15n 0.680 28n 0.680 34n 0.420 48n 0.420 80n 0.307]
Vclk (clk 0) vsource type=pulse val0=0 val1=0.9 period=6n width=3n delay=1n rise=60p fall=60p
Vrst (rst 0) vsource type=pwl wave=[0 0.9 2.1n 0.9 2.2n 0 80n 0]
Venable (enable 0) vsource type=pwl wave=[0 0 5n 0 5.1n 0.9 56n 0.9 56.1n 0 62n 0 62.1n 0.9 80n 0.9]

XDUT (i_in q_in clk rst enable i_out q_out amp_error_metric phase_error_metric balanced) polyphase_iq_balance_monitor_top

simulatorOptions options evas_profile=balanced

tran tran stop=80n maxstep=120p
save i_in q_in clk rst enable i_out q_out amp_error_metric phase_error_metric balanced
