`include "disciplines.vams"

module dac_ideal_4b_offset(din0, din1, din2, din3, dout);
input din0, din1, din2, din3;
output dout;
electrical din0, din1, din2, din3, dout;

analog begin
    V(dout) <+ 0;
end

endmodule
