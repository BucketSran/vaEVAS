`include "constants.vams"
`include "disciplines.vams"
module dut(vp,vn,clk);
inout vp,vn,clk; electrical vp,vn,clk;
// TODO: implement the required experiment and result ports.
endmodule
