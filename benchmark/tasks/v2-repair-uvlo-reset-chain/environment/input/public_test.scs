simulator lang=spectre
ahdl_include "dut.va"
ahdl_include "uvlo.va"
ahdl_include "release.va"
ahdl_include "enable.va"
ahdl_include "downstream.va"
Vvin (vin 0) vsource type=pwl wave=[0 0.5 2.199e-09 0.5 2.2e-09 0.7 2.0199e-08 0.7 2.02e-08 0.5 2.4199e-08 0.5 2.42e-08 0.7 2.7199e-08 0.7 2.72e-08 0.5 3.0199e-08 0.5 3.02e-08 0.7 4.9199e-08 0.7 4.92e-08 0.5 5.3199e-08 0.5 5.32e-08 0.7 7.8e-08 0.7]
Vclk (clk 0) vsource type=pwl wave=[0 0 9.99e-10 0 1e-09 0.9 1.399e-09 0.9 1.4e-09 0 1.999e-09 0 2e-09 0.9 2.399e-09 0.9 2.4e-09 0 2.999e-09 0 3e-09 0.9 3.399e-09 0.9 3.4e-09 0 3.999e-09 0 4e-09 0.9 4.399e-09 0.9 4.4e-09 0 4.999e-09 0 5e-09 0.9 5.399e-09 0.9 5.4e-09 0 5.999e-09 0 6e-09 0.9 6.399e-09 0.9 6.4e-09 0 6.999e-09 0 7e-09 0.9 7.399e-09 0.9 7.4e-09 0 7.999e-09 0 8e-09 0.9 8.399e-09 0.9 8.4e-09 0 8.999e-09 0 9e-09 0.9 9.399e-09 0.9 9.4e-09 0 9.999e-09 0 1e-08 0.9 1.0399e-08 0.9 1.04e-08 0 1.0999e-08 0 1.1e-08 0.9 1.1399e-08 0.9 1.14e-08 0 1.1999e-08 0 1.2e-08 0.9 1.2399e-08 0.9 1.24e-08 0 1.2999e-08 0 1.3e-08 0.9 1.3399e-08 0.9 1.34e-08 0 1.3999e-08 0 1.4e-08 0.9 1.4399e-08 0.9 1.44e-08 0 1.4999e-08 0 1.5e-08 0.9 1.5399e-08 0.9 1.54e-08 0 1.5999e-08 0 1.6e-08 0.9 1.6399e-08 0.9 1.64e-08 0 1.6999e-08 0 1.7e-08 0.9 1.7399e-08 0.9 1.74e-08 0 1.7999e-08 0 1.8e-08 0.9 1.8399e-08 0.9 1.84e-08 0 1.8999e-08 0 1.9e-08 0.9 1.9399e-08 0.9 1.94e-08 0 1.9999e-08 0 2e-08 0.9 2.0399e-08 0.9 2.04e-08 0 2.0999e-08 0 2.1e-08 0.9 2.1399e-08 0.9 2.14e-08 0 2.1999e-08 0 2.2e-08 0.9 2.2399e-08 0.9 2.24e-08 0 2.2999e-08 0 2.3e-08 0.9 2.3399e-08 0.9 2.34e-08 0 2.3999e-08 0 2.4e-08 0.9 2.4399e-08 0.9 2.44e-08 0 2.4999e-08 0 2.5e-08 0.9 2.5399e-08 0.9 2.54e-08 0 2.5999e-08 0 2.6e-08 0.9 2.6399e-08 0.9 2.64e-08 0 2.6999e-08 0 2.7e-08 0.9 2.7399e-08 0.9 2.74e-08 0 2.7999e-08 0 2.8e-08 0.9 2.8399e-08 0.9 2.84e-08 0 2.8999e-08 0 2.9e-08 0.9 2.9399e-08 0.9 2.94e-08 0 2.9999e-08 0 3e-08 0.9 3.0399e-08 0.9 3.04e-08 0 3.0999e-08 0 3.1e-08 0.9 3.1399e-08 0.9 3.14e-08 0 3.1999e-08 0 3.2e-08 0.9 3.2399e-08 0.9 3.24e-08 0 3.2999e-08 0 3.3e-08 0.9 3.3399e-08 0.9 3.34e-08 0 3.3999e-08 0 3.4e-08 0.9 3.4399e-08 0.9 3.44e-08 0 3.4999e-08 0 3.5e-08 0.9 3.5399e-08 0.9 3.54e-08 0 3.5999e-08 0 3.6e-08 0.9 3.6399e-08 0.9 3.64e-08 0 3.6999e-08 0 3.7e-08 0.9 3.7399e-08 0.9 3.74e-08 0 3.7999e-08 0 3.8e-08 0.9 3.8399e-08 0.9 3.84e-08 0 3.8999e-08 0 3.9e-08 0.9 3.9399e-08 0.9 3.94e-08 0 3.9999e-08 0 4e-08 0.9 4.0399e-08 0.9 4.04e-08 0 4.0999e-08 0 4.1e-08 0.9 4.1399e-08 0.9 4.14e-08 0 4.1999e-08 0 4.2e-08 0.9 4.2399e-08 0.9 4.24e-08 0 4.2999e-08 0 4.3e-08 0.9 4.3399e-08 0.9 4.34e-08 0 4.3999e-08 0 4.4e-08 0.9 4.4399e-08 0.9 4.44e-08 0 4.4999e-08 0 4.5e-08 0.9 4.5399e-08 0.9 4.54e-08 0 4.5999e-08 0 4.6e-08 0.9 4.6399e-08 0.9 4.64e-08 0 4.6999e-08 0 4.7e-08 0.9 4.7399e-08 0.9 4.74e-08 0 4.7999e-08 0 4.8e-08 0.9 4.8399e-08 0.9 4.84e-08 0 4.8999e-08 0 4.9e-08 0.9 4.9399e-08 0.9 4.94e-08 0 4.9999e-08 0 5e-08 0.9 5.0399e-08 0.9 5.04e-08 0 5.0999e-08 0 5.1e-08 0.9 5.1399e-08 0.9 5.14e-08 0 5.1999e-08 0 5.2e-08 0.9 5.2399e-08 0.9 5.24e-08 0 5.2999e-08 0 5.3e-08 0.9 5.3399e-08 0.9 5.34e-08 0 5.3999e-08 0 5.4e-08 0.9 5.4399e-08 0.9 5.44e-08 0 5.4999e-08 0 5.5e-08 0.9 5.5399e-08 0.9 5.54e-08 0 5.5999e-08 0 5.6e-08 0.9 5.6399e-08 0.9 5.64e-08 0 5.6999e-08 0 5.7e-08 0.9 5.7399e-08 0.9 5.74e-08 0 5.7999e-08 0 5.8e-08 0.9 5.8399e-08 0.9 5.84e-08 0 5.8999e-08 0 5.9e-08 0.9 5.9399e-08 0.9 5.94e-08 0 5.9999e-08 0 6e-08 0.9 6.0399e-08 0.9 6.04e-08 0 6.0999e-08 0 6.1e-08 0.9 6.1399e-08 0.9 6.14e-08 0 6.1999e-08 0 6.2e-08 0.9 6.2399e-08 0.9 6.24e-08 0 6.2999e-08 0 6.3e-08 0.9 6.3399e-08 0.9 6.34e-08 0 6.3999e-08 0 6.4e-08 0.9 6.4399e-08 0.9 6.44e-08 0 6.4999e-08 0 6.5e-08 0.9 6.5399e-08 0.9 6.54e-08 0 6.5999e-08 0 6.6e-08 0.9 6.6399e-08 0.9 6.64e-08 0 6.6999e-08 0 6.7e-08 0.9 6.7399e-08 0.9 6.74e-08 0 6.7999e-08 0 6.8e-08 0.9 6.8399e-08 0.9 6.84e-08 0 6.8999e-08 0 6.9e-08 0.9 6.9399e-08 0.9 6.94e-08 0 6.9999e-08 0 7e-08 0.9 7.0399e-08 0.9 7.04e-08 0 7.0999e-08 0 7.1e-08 0.9 7.1399e-08 0.9 7.14e-08 0 7.1999e-08 0 7.2e-08 0.9 7.2399e-08 0.9 7.24e-08 0 7.2999e-08 0 7.3e-08 0.9 7.3399e-08 0.9 7.34e-08 0 7.3999e-08 0 7.4e-08 0.9 7.4399e-08 0.9 7.44e-08 0 7.4999e-08 0 7.5e-08 0.9 7.5399e-08 0.9 7.54e-08 0 7.5999e-08 0 7.6e-08 0.9 7.6399e-08 0.9 7.64e-08 0 7.6999e-08 0 7.7e-08 0.9 7.7399e-08 0.9 7.74e-08 0 7.8e-08 0]
Xdut (vin clk pgood resetb enable activity) power_chain
simulatorOptions options reltol=1e-6 vabstol=1e-8
tran tran stop=7.8e-08 maxstep=5e-11
save vin clk pgood resetb enable activity
