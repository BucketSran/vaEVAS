`include "constants.vams"
`include "disciplines.vams"

module sample_phase_cell(vin, phi1, phi2, rst, enable, sample_node, sample_valid);
    input vin, phi1, phi2, rst, enable;
    output sample_node, sample_valid;
    electrical vin, phi1, phi2, rst, enable, sample_node, sample_valid;

    parameter real vdd = 0.9;
    parameter real vss = 0.0;
    parameter real vcm = 0.45;
    parameter real vth = 0.45;
    parameter real tr = 200p from (0:inf);
    real sample_v, valid_v;

    analog function real clip01;
        input x;
        real x;
        begin
            if (x < vss) clip01 = vss;
            else if (x > vdd) clip01 = vdd;
            else clip01 = x;
        end
    endfunction

    analog begin
        @(initial_step) begin sample_v = vcm; valid_v = vss; end
 @(cross(V(rst)-vth,+1) or cross(V(enable)-vth,-1)) begin sample_v = vcm; valid_v = vss; end
        @(cross(V(phi1) - vth, +1)) begin
            if ((V(rst) > vth || V(enable) <= vth)) begin
                sample_v = vcm;
                valid_v = vss;
            end else if (V(phi2) <= vth || 0) begin
                sample_v = V(vin);
                valid_v = vdd;
            end else begin
                valid_v = vss;
            end
        end
        V(sample_node) <+ transition(clip01(sample_v), 0, tr, tr);
        V(sample_valid) <+ transition(valid_v, 0, tr, tr);
    end
endmodule
