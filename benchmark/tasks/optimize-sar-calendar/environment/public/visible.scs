simulator lang=spectre
global 0
ahdl_include "/work/dut.va"
VVIN (vin 0) vsource type=pwl wave=[0 0.17000000000000001 8.9999999999999996e-07 0.17000000000000001 9.0009999999999997e-07 0.178558349609375 1.1999999999999999e-06 0.178558349609375 1.2001e-06 0.821380615234375 5.9000000000000003e-06 0.821380615234375 5.9001000000000005e-06 0.421966552734375 6.1999999999999999e-06 0.421966552734375 6.2001000000000002e-06 0.577972412109375 1.0900000000000001e-05 0.577972412109375 1.0900100000000001e-05 0.665374755859375 1.1200000000000001e-05 0.665374755859375 1.1200100000000001e-05 0.334564208984375 1.5900000000000004e-05 0.334564208984375 1.5900100000000004e-05 0.908782958984375 1.6200000000000004e-05 0.908782958984375 1.6200100000000001e-05 0.091156005859375 2.0900000000000003e-05 0.091156005859375 2.0900100000000003e-05 0.152191162109375 2.1200000000000004e-05 0.152191162109375 2.1200100000000001e-05 0.847747802734375 2.5900000000000003e-05 0.847747802734375 2.5900100000000003e-05 0.395599365234375 2.6200000000000003e-05 0.395599365234375 2.62001e-05 0.604339599609375 3.0899999999999999e-05 0.604339599609375 3.0900099999999999e-05 0.639007568359375 3.1199999999999999e-05 0.639007568359375 3.12001e-05 0.360931396484375 3.5899999999999998e-05 0.360931396484375 3.5900099999999999e-05 0.882415771484375 3.6199999999999999e-05 0.882415771484375 3.6200099999999999e-05 0.117523193359375 4.0899999999999998e-05 0.117523193359375 4.0900099999999998e-05 0.125823974609375 4.1199999999999999e-05 0.125823974609375 4.1200099999999999e-05 0.874114990234375 4.5899999999999998e-05 0.874114990234375 4.5900099999999998e-05 0.369232177734375 4.6199999999999998e-05 0.369232177734375 4.6200099999999998e-05 0.630706787109375 5.0899999999999997e-05 0.630706787109375 5.0900099999999997e-05 0.612640380859375 5.1199999999999998e-05 0.612640380859375 5.1200099999999998e-05 0.387298583984375 5.5899999999999997e-05 0.387298583984375 5.5900099999999997e-05 0.856048583984375 5.6199999999999997e-05 0.856048583984375 5.6200099999999997e-05 0.143890380859375 6.0900000000000003e-05 0.143890380859375 6.0900100000000003e-05 0.099456787109375 6.120000000000001e-05 0.099456787109375 6.1200100000000004e-05 0.900482177734375 6.5900000000000003e-05 0.900482177734375 6.590010000000001e-05 0.342864990234375 6.620000000000001e-05 0.342864990234375 6.6200100000000003e-05 0.657073974609375 7.0900000000000002e-05 0.657073974609375 7.0900100000000009e-05 0.586273193359375 7.1200000000000009e-05 0.586273193359375 7.1200100000000003e-05 0.413665771484375 7.5900000000000002e-05 0.413665771484375 7.5900100000000009e-05 0.829681396484375 7.6200000000000009e-05 0.829681396484375 7.6200100000000002e-05 0.170257568359375 8.0900000000000001e-05 0.170257568359375 8.0900100000000008e-05 0.073089599609375 8.1200000000000009e-05 0.073089599609375 8.1200100000000002e-05 0.926849365234375 8.5900000000000001e-05 0.926849365234375 8.5900100000000008e-05 0.316497802734375 8.6200000000000008e-05 0.316497802734375 8.6200100000000002e-05 0.683441162109375 9.09e-05 0.683441162109375 9.0900100000000007e-05 0.559906005859375 9.1200000000000008e-05 0.559906005859375 9.1200100000000001e-05 0.440032958984375 9.59e-05 0.440032958984375 9.5900100000000007e-05 0.803314208984375 9.6200000000000007e-05 0.803314208984375 9.6200100000000001e-05 0.196624755859375 0.0001 0.196624755859375]
VSTART (start 0) vsource type=pwl wave=[0 0 9.9999999999999995e-07 0 1.0001e-06 1 1.02e-06 1 1.0201e-06 0 6.0000000000000002e-06 0 6.0001000000000004e-06 1 6.02e-06 1 6.0201000000000002e-06 0 1.1000000000000001e-05 0 1.1000100000000002e-05 1 1.1020000000000001e-05 1 1.1020100000000001e-05 0 1.6000000000000003e-05 0 1.6000100000000003e-05 1 1.6020000000000002e-05 1 1.6020100000000003e-05 0 2.1000000000000002e-05 0 2.1000100000000002e-05 1 2.1020000000000002e-05 1 2.1020100000000002e-05 0 2.6000000000000002e-05 0 2.6000100000000002e-05 1 2.6020000000000002e-05 1 2.6020100000000002e-05 0 3.1000000000000001e-05 0 3.1000100000000002e-05 1 3.1020000000000005e-05 1 3.1020100000000005e-05 0 3.6000000000000001e-05 0 3.6000100000000001e-05 1 3.6020000000000004e-05 1 3.6020100000000004e-05 0 4.1e-05 0 4.1000100000000001e-05 1 4.1020000000000004e-05 1 4.1020100000000004e-05 0 4.6e-05 0 4.60001e-05 1 4.6020000000000003e-05 1 4.6020100000000003e-05 0 5.1e-05 0 5.10001e-05 1 5.1020000000000003e-05 1 5.1020100000000003e-05 0 5.5999999999999999e-05 0 5.6000099999999999e-05 1 5.6020000000000002e-05 1 5.6020100000000003e-05 0 6.1000000000000005e-05 0 6.1000100000000006e-05 1 6.1020000000000009e-05 1 6.1020100000000009e-05 0 6.6000000000000005e-05 0 6.6000099999999999e-05 1 6.6020000000000008e-05 1 6.6020100000000002e-05 0 7.1000000000000005e-05 0 7.1000099999999998e-05 1 7.1020000000000008e-05 1 7.1020100000000001e-05 0 7.6000000000000004e-05 0 7.6000099999999998e-05 1 7.6020000000000007e-05 1 7.6020100000000001e-05 0 8.1000000000000004e-05 0 8.1000099999999997e-05 1 8.1020000000000007e-05 1 8.10201e-05 0 8.6000000000000003e-05 0 8.6000099999999997e-05 1 8.6020000000000007e-05 1 8.60201e-05 0 9.1000000000000003e-05 0 9.1000099999999996e-05 1 9.1020000000000006e-05 1 9.10201e-05 0 9.6000000000000002e-05 0 9.6000099999999996e-05 1 9.6020000000000006e-05 1 9.6020099999999999e-05 0 0.0001 0]
VRESET (reset 0) vsource type=pwl wave=[0 0 0.0001 0]
DUT (vin start reset busy valid code dac) sensor_sar vref=1.0 bit_period=5e-08
simulatorOptions options reltol=1e-6 vabstol=1e-9 iabstol=1e-14
tran tran stop=0.0001 errpreset=conservative
save vin start reset busy valid code dac
