`include "disciplines.vams"
// Original 12-bit sensor SAR control model: sample once, test one bit per
// conversion interval, hold completed code until next completion or reset.
module sensor_sar(vin, start, reset, busy, valid, code, dac);
 input vin,start,reset;
 output busy,valid,code,dac;
 electrical vin,start,reset,busy,valid,code,dac;
 parameter real vref=1.0 from (0:inf);
 parameter real bit_period=50n from (0:inf);
 parameter real poll_period=10n from (0:inf);
 parameter real rise=0.5n from (0:inf);
 integer active, ready, held_code, partial, bit_index, previous_start, trial;
 real sampled, next_bit;
 analog begin
  @(initial_step) begin
   active=0;ready=0;held_code=0;partial=0;trial=0;bit_index=11;
   previous_start=0;sampled=0;next_bit=1e30;
  end
  @(timer(0,poll_period)) begin
   if(V(reset)>=0.5) begin
    active=0;ready=0;held_code=0;partial=0;trial=0;next_bit=1e30;
   end else begin
    if(V(start)>=0.5 && !previous_start && !active) begin
     sampled=V(vin);partial=0;bit_index=11;trial=2048;active=1;ready=0;
     next_bit=$abstime+bit_period;
    end
    if(active && $abstime+1e-6*poll_period>=next_bit) begin
     if(sampled>=vref*trial/4096.0) partial=trial;
     if(bit_index==0) begin
      held_code=partial;trial=partial;active=0;ready=1;next_bit=1e30;
     end else begin bit_index=bit_index-1;trial=partial+(1<<bit_index);next_bit=next_bit+bit_period;end
    end
   end
   previous_start=(V(start)>=0.5);
  end
  V(busy) <+ transition(active,0,rise);
  V(valid) <+ transition(ready,0,rise);
  V(dac) <+ transition(trial/4096.0,0,rise);
  V(code) <+ transition(held_code/4095.0,0,rise);
 end
endmodule
