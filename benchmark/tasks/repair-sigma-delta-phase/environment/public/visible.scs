simulator lang=spectre
global 0
ahdl_include "../dut.va"
Vvin (vin 0) vsource type=pwl wave=[0 0.25 4.948e-08 0.25 4.952e-08 0.625]
Vclk (clk 0) vsource type=pwl wave=[0 0 1.98e-09 0 2.02e-09 1 2.78e-09 1 2.82e-09 0 3.98e-09 0 4.02e-09 1 4.78e-09 1 4.82e-09 0 5.98e-09 0 6.02e-09 1 6.78e-09 1 6.82e-09 0 7.98e-09 0 8.02e-09 1 8.78e-09 1 8.82e-09 0 9.98e-09 0 1.002e-08 1 1.078e-08 1 1.082e-08 0 1.198e-08 0 1.202e-08 1 1.278e-08 1 1.282e-08 0 1.398e-08 0 1.402e-08 1 1.478e-08 1 1.482e-08 0 1.598e-08 0 1.602e-08 1 1.678e-08 1 1.682e-08 0 1.798e-08 0 1.802e-08 1 1.878e-08 1 1.882e-08 0 1.998e-08 0 2.002e-08 1 2.078e-08 1 2.082e-08 0 2.198e-08 0 2.202e-08 1 2.278e-08 1 2.282e-08 0 2.398e-08 0 2.402e-08 1 2.478e-08 1 2.482e-08 0 2.598e-08 0 2.602e-08 1 2.678e-08 1 2.682e-08 0 2.798e-08 0 2.802e-08 1 2.878e-08 1 2.882e-08 0 2.998e-08 0 3.002e-08 1 3.078e-08 1 3.082e-08 0 3.198e-08 0 3.202e-08 1 3.278e-08 1 3.282e-08 0 3.398e-08 0 3.402e-08 1 3.478e-08 1 3.482e-08 0 3.598e-08 0 3.602e-08 1 3.678e-08 1 3.682e-08 0 3.798e-08 0 3.802e-08 1 3.878e-08 1 3.882e-08 0 3.998e-08 0 4.002e-08 1 4.078e-08 1 4.082e-08 0 4.198e-08 0 4.202e-08 1 4.278e-08 1 4.282e-08 0 4.398e-08 0 4.402e-08 1 4.478e-08 1 4.482e-08 0 4.598e-08 0 4.602e-08 1 4.678e-08 1 4.682e-08 0 4.798e-08 0 4.802e-08 1 4.878e-08 1 4.882e-08 0 4.998e-08 0 5.002e-08 1 5.078e-08 1 5.082e-08 0 5.198e-08 0 5.202e-08 1 5.278e-08 1 5.282e-08 0 5.398e-08 0 5.402e-08 1 5.478e-08 1 5.482e-08 0 5.598e-08 0 5.602e-08 1 5.678e-08 1 5.682e-08 0 5.798e-08 0 5.802e-08 1 5.878e-08 1 5.882e-08 0 5.998e-08 0 6.002e-08 1 6.078e-08 1 6.082e-08 0 6.198e-08 0 6.202e-08 1 6.278e-08 1 6.282e-08 0 6.398e-08 0 6.402e-08 1 6.478e-08 1 6.482e-08 0 6.598e-08 0 6.602e-08 1 6.678e-08 1 6.682e-08 0 6.798e-08 0 6.802e-08 1 6.878e-08 1 6.882e-08 0 6.998e-08 0 7.002e-08 1 7.078e-08 1 7.082e-08 0 7.198e-08 0 7.202e-08 1 7.278e-08 1 7.282e-08 0 7.398e-08 0 7.402e-08 1 7.478e-08 1 7.482e-08 0 7.598e-08 0 7.602e-08 1 7.678e-08 1 7.682e-08 0 7.798e-08 0 7.802e-08 1 7.878e-08 1 7.882e-08 0 7.998e-08 0 8.002e-08 1 8.078e-08 1 8.082e-08 0 8.198e-08 0 8.202e-08 1 8.278e-08 1 8.282e-08 0 8.398e-08 0 8.402e-08 1 8.478e-08 1 8.482e-08 0 8.598e-08 0 8.602e-08 1 8.678e-08 1 8.682e-08 0 8.798e-08 0 8.802e-08 1 8.878e-08 1 8.882e-08 0 8.998e-08 0 9.002e-08 1 9.078e-08 1 9.082e-08 0 9.198e-08 0 9.202e-08 1 9.278e-08 1 9.282e-08 0 9.398e-08 0 9.402e-08 1 9.478e-08 1 9.482e-08 0 9.598e-08 0 9.602e-08 1 9.678e-08 1 9.682e-08 0]
XDUT (vin clk bitout) sigma_delta
simulatorOptions options reltol=1e-6 vabstol=1e-9
tran tran stop=9.8e-08 maxstep=3e-11
save vin clk bitout
