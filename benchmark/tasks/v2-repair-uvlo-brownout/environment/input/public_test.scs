simulator lang=spectre
ahdl_include "dut.va"
Vclk (clk 0) vsource type=pwl wave=[0 0 9.99e-10 0 1e-09 0.9 1.399e-09 0.9 1.4e-09 0 1.999e-09 0 2e-09 0.9 2.399e-09 0.9 2.4e-09 0 2.999e-09 0 3e-09 0.9 3.399e-09 0.9 3.4e-09 0 3.999e-09 0 4e-09 0.9 4.399e-09 0.9 4.4e-09 0 4.999e-09 0 5e-09 0.9 5.399e-09 0.9 5.4e-09 0 5.999e-09 0 6e-09 0.9 6.399e-09 0.9 6.4e-09 0 6.999e-09 0 7e-09 0.9 7.399e-09 0.9 7.4e-09 0 7.999e-09 0 8e-09 0.9 8.399e-09 0.9 8.4e-09 0 8.999e-09 0 9e-09 0.9 9.399e-09 0.9 9.4e-09 0 9.999e-09 0 1e-08 0.9 1.0399e-08 0.9 1.04e-08 0 1.0999e-08 0 1.1e-08 0.9 1.1399e-08 0.9 1.14e-08 0 1.1999e-08 0 1.2e-08 0.9 1.2399e-08 0.9 1.24e-08 0 1.2999e-08 0 1.3e-08 0.9 1.3399e-08 0.9 1.34e-08 0 1.3999e-08 0 1.4e-08 0.9 1.4399e-08 0.9 1.44e-08 0 1.4999e-08 0 1.5e-08 0.9 1.5399e-08 0.9 1.54e-08 0 1.5999e-08 0 1.6e-08 0.9 1.6399e-08 0.9 1.64e-08 0 1.6999e-08 0 1.7e-08 0.9 1.7399e-08 0.9 1.74e-08 0 1.7999e-08 0 1.8e-08 0.9 1.8399e-08 0.9 1.84e-08 0 1.8999e-08 0 1.9e-08 0.9 1.9399e-08 0.9 1.94e-08 0 2e-08 0]
Vrst (rst 0) vsource type=pwl wave=[0 0 1.1599e-08 0 1.16e-08 0.9 1.2399e-08 0.9 1.24e-08 0 2e-08 0]
Vvin (vin 0) vsource type=pwl wave=[0 0.5 2.599e-09 0.5 2.6e-09 0.7 5.599e-09 0.7 5.6e-09 0.6 8.599e-09 0.6 8.6e-09 0.5 1.0599e-08 0.5 1.06e-08 0.7 1.5599e-08 0.7 1.56e-08 0.6 1.7599e-08 0.6 1.76e-08 0.5 2e-08 0.5]
Xdut (clk rst vin out metric) uvlo_brownout_detector
simulatorOptions options reltol=1e-6 vabstol=1e-8
tran tran stop=2e-08 maxstep=5e-11
save clk rst vin out metric
