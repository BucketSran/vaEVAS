`include "constants.vams"
`include "disciplines.vams"
module dut(ref,clk,verdict);
inout ref,clk,verdict; electrical ref,clk,verdict;
// TODO: implement the required experiment and result ports.
endmodule
