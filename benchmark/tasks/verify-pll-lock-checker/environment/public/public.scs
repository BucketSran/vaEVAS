simulator lang=spectre
ahdl_include "dut.va"
ahdl_include "device.va"
Xmon (ref clk verdict) dut
Xpll (ref clk) pll_device fault=0
simulatorOptions options reltol=1e-6 vabstol=1e-9
tran tran stop=4u maxstep=1n
saveOptions options save=allpub
