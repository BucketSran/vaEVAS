`include "disciplines.vams"
module fixture_adc(vin,clk,dout);
input vin,clk;
output [7:0] dout;
electrical vin,clk;
electrical [7:0] dout;
integer code;
analog begin
    @(initial_step) code=0;
    @(cross(V(clk)-0.5,+1)) begin
        code=0;
            if (V(vin) >= 0.0048828125) code = code + 1;
            if (V(vin) >= 0.0068359375) code = code + 1;
            if (V(vin) >= 0.0126953125) code = code + 1;
            if (V(vin) >= 0.0146484375) code = code + 1;
            if (V(vin) >= 0.0205078125) code = code + 1;
            if (V(vin) >= 0.0224609375) code = code + 1;
            if (V(vin) >= 0.0283203125) code = code + 1;
            if (V(vin) >= 0.0302734375) code = code + 1;
            if (V(vin) >= 0.0361328125) code = code + 1;
            if (V(vin) >= 0.0380859375) code = code + 1;
            if (V(vin) >= 0.0439453125) code = code + 1;
            if (V(vin) >= 0.0458984375) code = code + 1;
            if (V(vin) >= 0.0517578125) code = code + 1;
            if (V(vin) >= 0.0537109375) code = code + 1;
            if (V(vin) >= 0.0595703125) code = code + 1;
            if (V(vin) >= 0.0615234375) code = code + 1;
            if (V(vin) >= 0.0673828125) code = code + 1;
            if (V(vin) >= 0.0693359375) code = code + 1;
            if (V(vin) >= 0.0751953125) code = code + 1;
            if (V(vin) >= 0.0771484375) code = code + 1;
            if (V(vin) >= 0.0830078125) code = code + 1;
            if (V(vin) >= 0.0849609375) code = code + 1;
            if (V(vin) >= 0.0908203125) code = code + 1;
            if (V(vin) >= 0.0927734375) code = code + 1;
            if (V(vin) >= 0.0986328125) code = code + 1;
            if (V(vin) >= 0.1005859375) code = code + 1;
            if (V(vin) >= 0.1064453125) code = code + 1;
            if (V(vin) >= 0.1083984375) code = code + 1;
            if (V(vin) >= 0.1142578125) code = code + 1;
            if (V(vin) >= 0.1162109375) code = code + 1;
            if (V(vin) >= 0.1220703125) code = code + 1;
            if (V(vin) >= 0.1240234375) code = code + 1;
            if (V(vin) >= 0.1298828125) code = code + 1;
            if (V(vin) >= 0.1318359375) code = code + 1;
            if (V(vin) >= 0.1376953125) code = code + 1;
            if (V(vin) >= 0.1396484375) code = code + 1;
            if (V(vin) >= 0.1455078125) code = code + 1;
            if (V(vin) >= 0.1474609375) code = code + 1;
            if (V(vin) >= 0.1533203125) code = code + 1;
            if (V(vin) >= 0.1552734375) code = code + 1;
            if (V(vin) >= 0.1611328125) code = code + 1;
            if (V(vin) >= 0.1630859375) code = code + 1;
            if (V(vin) >= 0.1689453125) code = code + 1;
            if (V(vin) >= 0.1708984375) code = code + 1;
            if (V(vin) >= 0.1767578125) code = code + 1;
            if (V(vin) >= 0.1787109375) code = code + 1;
            if (V(vin) >= 0.1845703125) code = code + 1;
            if (V(vin) >= 0.1865234375) code = code + 1;
            if (V(vin) >= 0.1923828125) code = code + 1;
            if (V(vin) >= 0.1943359375) code = code + 1;
            if (V(vin) >= 0.2001953125) code = code + 1;
            if (V(vin) >= 0.2021484375) code = code + 1;
            if (V(vin) >= 0.2080078125) code = code + 1;
            if (V(vin) >= 0.2099609375) code = code + 1;
            if (V(vin) >= 0.2158203125) code = code + 1;
            if (V(vin) >= 0.2177734375) code = code + 1;
            if (V(vin) >= 0.2236328125) code = code + 1;
            if (V(vin) >= 0.2255859375) code = code + 1;
            if (V(vin) >= 0.2314453125) code = code + 1;
            if (V(vin) >= 0.2333984375) code = code + 1;
            if (V(vin) >= 0.2392578125) code = code + 1;
            if (V(vin) >= 0.2412109375) code = code + 1;
            if (V(vin) >= 0.2470703125) code = code + 1;
            if (V(vin) >= 0.2490234375) code = code + 1;
            if (V(vin) >= 0.2548828125) code = code + 1;
            if (V(vin) >= 0.2568359375) code = code + 1;
            if (V(vin) >= 0.2626953125) code = code + 1;
            if (V(vin) >= 0.2646484375) code = code + 1;
            if (V(vin) >= 0.2705078125) code = code + 1;
            if (V(vin) >= 0.2724609375) code = code + 1;
            if (V(vin) >= 0.2783203125) code = code + 1;
            if (V(vin) >= 0.2802734375) code = code + 1;
            if (V(vin) >= 0.2861328125) code = code + 1;
            if (V(vin) >= 0.2880859375) code = code + 1;
            if (V(vin) >= 0.2939453125) code = code + 1;
            if (V(vin) >= 0.2958984375) code = code + 1;
            if (V(vin) >= 0.3017578125) code = code + 1;
            if (V(vin) >= 0.3037109375) code = code + 1;
            if (V(vin) >= 0.3095703125) code = code + 1;
            if (V(vin) >= 0.3115234375) code = code + 1;
            if (V(vin) >= 0.3173828125) code = code + 1;
            if (V(vin) >= 0.3193359375) code = code + 1;
            if (V(vin) >= 0.3251953125) code = code + 1;
            if (V(vin) >= 0.3271484375) code = code + 1;
            if (V(vin) >= 0.3330078125) code = code + 1;
            if (V(vin) >= 0.3349609375) code = code + 1;
            if (V(vin) >= 0.3408203125) code = code + 1;
            if (V(vin) >= 0.3427734375) code = code + 1;
            if (V(vin) >= 0.3486328125) code = code + 1;
            if (V(vin) >= 0.3505859375) code = code + 1;
            if (V(vin) >= 0.3564453125) code = code + 1;
            if (V(vin) >= 0.3583984375) code = code + 1;
            if (V(vin) >= 0.3642578125) code = code + 1;
            if (V(vin) >= 0.3662109375) code = code + 1;
            if (V(vin) >= 0.3720703125) code = code + 1;
            if (V(vin) >= 0.3740234375) code = code + 1;
            if (V(vin) >= 0.3798828125) code = code + 1;
            if (V(vin) >= 0.3818359375) code = code + 1;
            if (V(vin) >= 0.3876953125) code = code + 1;
            if (V(vin) >= 0.3896484375) code = code + 1;
            if (V(vin) >= 0.3955078125) code = code + 1;
            if (V(vin) >= 0.3974609375) code = code + 1;
            if (V(vin) >= 0.4033203125) code = code + 1;
            if (V(vin) >= 0.4052734375) code = code + 1;
            if (V(vin) >= 0.4111328125) code = code + 1;
            if (V(vin) >= 0.4130859375) code = code + 1;
            if (V(vin) >= 0.4189453125) code = code + 1;
            if (V(vin) >= 0.4208984375) code = code + 1;
            if (V(vin) >= 0.4267578125) code = code + 1;
            if (V(vin) >= 0.4287109375) code = code + 1;
            if (V(vin) >= 0.4345703125) code = code + 1;
            if (V(vin) >= 0.4365234375) code = code + 1;
            if (V(vin) >= 0.4423828125) code = code + 1;
            if (V(vin) >= 0.4443359375) code = code + 1;
            if (V(vin) >= 0.4501953125) code = code + 1;
            if (V(vin) >= 0.4521484375) code = code + 1;
            if (V(vin) >= 0.4580078125) code = code + 1;
            if (V(vin) >= 0.4599609375) code = code + 1;
            if (V(vin) >= 0.4658203125) code = code + 1;
            if (V(vin) >= 0.4677734375) code = code + 1;
            if (V(vin) >= 0.4736328125) code = code + 1;
            if (V(vin) >= 0.4755859375) code = code + 1;
            if (V(vin) >= 0.4814453125) code = code + 1;
            if (V(vin) >= 0.4833984375) code = code + 1;
            if (V(vin) >= 0.4892578125) code = code + 1;
            if (V(vin) >= 0.4912109375) code = code + 1;
            if (V(vin) >= 0.4970703125) code = code + 1;
            if (V(vin) >= 0.4990234375) code = code + 1;
            if (V(vin) >= 0.5048828125) code = code + 1;
            if (V(vin) >= 0.5068359375) code = code + 1;
            if (V(vin) >= 0.5126953125) code = code + 1;
            if (V(vin) >= 0.5146484375) code = code + 1;
            if (V(vin) >= 0.5205078125) code = code + 1;
            if (V(vin) >= 0.5224609375) code = code + 1;
            if (V(vin) >= 0.5283203125) code = code + 1;
            if (V(vin) >= 0.5302734375) code = code + 1;
            if (V(vin) >= 0.5361328125) code = code + 1;
            if (V(vin) >= 0.5380859375) code = code + 1;
            if (V(vin) >= 0.5439453125) code = code + 1;
            if (V(vin) >= 0.5458984375) code = code + 1;
            if (V(vin) >= 0.5517578125) code = code + 1;
            if (V(vin) >= 0.5537109375) code = code + 1;
            if (V(vin) >= 0.5595703125) code = code + 1;
            if (V(vin) >= 0.5615234375) code = code + 1;
            if (V(vin) >= 0.5673828125) code = code + 1;
            if (V(vin) >= 0.5693359375) code = code + 1;
            if (V(vin) >= 0.5751953125) code = code + 1;
            if (V(vin) >= 0.5771484375) code = code + 1;
            if (V(vin) >= 0.5830078125) code = code + 1;
            if (V(vin) >= 0.5849609375) code = code + 1;
            if (V(vin) >= 0.5908203125) code = code + 1;
            if (V(vin) >= 0.5927734375) code = code + 1;
            if (V(vin) >= 0.5986328125) code = code + 1;
            if (V(vin) >= 0.6005859375) code = code + 1;
            if (V(vin) >= 0.6064453125) code = code + 1;
            if (V(vin) >= 0.6083984375) code = code + 1;
            if (V(vin) >= 0.6142578125) code = code + 1;
            if (V(vin) >= 0.6162109375) code = code + 1;
            if (V(vin) >= 0.6220703125) code = code + 1;
            if (V(vin) >= 0.6240234375) code = code + 1;
            if (V(vin) >= 0.6298828125) code = code + 1;
            if (V(vin) >= 0.6318359375) code = code + 1;
            if (V(vin) >= 0.6376953125) code = code + 1;
            if (V(vin) >= 0.6396484375) code = code + 1;
            if (V(vin) >= 0.6455078125) code = code + 1;
            if (V(vin) >= 0.6474609375) code = code + 1;
            if (V(vin) >= 0.6533203125) code = code + 1;
            if (V(vin) >= 0.6552734375) code = code + 1;
            if (V(vin) >= 0.6611328125) code = code + 1;
            if (V(vin) >= 0.6630859375) code = code + 1;
            if (V(vin) >= 0.6689453125) code = code + 1;
            if (V(vin) >= 0.6708984375) code = code + 1;
            if (V(vin) >= 0.6767578125) code = code + 1;
            if (V(vin) >= 0.6787109375) code = code + 1;
            if (V(vin) >= 0.6845703125) code = code + 1;
            if (V(vin) >= 0.6865234375) code = code + 1;
            if (V(vin) >= 0.6923828125) code = code + 1;
            if (V(vin) >= 0.6943359375) code = code + 1;
            if (V(vin) >= 0.7001953125) code = code + 1;
            if (V(vin) >= 0.7021484375) code = code + 1;
            if (V(vin) >= 0.7080078125) code = code + 1;
            if (V(vin) >= 0.7099609375) code = code + 1;
            if (V(vin) >= 0.7158203125) code = code + 1;
            if (V(vin) >= 0.7177734375) code = code + 1;
            if (V(vin) >= 0.7236328125) code = code + 1;
            if (V(vin) >= 0.7255859375) code = code + 1;
            if (V(vin) >= 0.7314453125) code = code + 1;
            if (V(vin) >= 0.7333984375) code = code + 1;
            if (V(vin) >= 0.7392578125) code = code + 1;
            if (V(vin) >= 0.7412109375) code = code + 1;
            if (V(vin) >= 0.7470703125) code = code + 1;
            if (V(vin) >= 0.7490234375) code = code + 1;
            if (V(vin) >= 0.7548828125) code = code + 1;
            if (V(vin) >= 0.7568359375) code = code + 1;
            if (V(vin) >= 0.7626953125) code = code + 1;
            if (V(vin) >= 0.7646484375) code = code + 1;
            if (V(vin) >= 0.7705078125) code = code + 1;
            if (V(vin) >= 0.7724609375) code = code + 1;
            if (V(vin) >= 0.7783203125) code = code + 1;
            if (V(vin) >= 0.7802734375) code = code + 1;
            if (V(vin) >= 0.7861328125) code = code + 1;
            if (V(vin) >= 0.7880859375) code = code + 1;
            if (V(vin) >= 0.7939453125) code = code + 1;
            if (V(vin) >= 0.7958984375) code = code + 1;
            if (V(vin) >= 0.8017578125) code = code + 1;
            if (V(vin) >= 0.8037109375) code = code + 1;
            if (V(vin) >= 0.8095703125) code = code + 1;
            if (V(vin) >= 0.8115234375) code = code + 1;
            if (V(vin) >= 0.8173828125) code = code + 1;
            if (V(vin) >= 0.8193359375) code = code + 1;
            if (V(vin) >= 0.8251953125) code = code + 1;
            if (V(vin) >= 0.8271484375) code = code + 1;
            if (V(vin) >= 0.8330078125) code = code + 1;
            if (V(vin) >= 0.8349609375) code = code + 1;
            if (V(vin) >= 0.8408203125) code = code + 1;
            if (V(vin) >= 0.8427734375) code = code + 1;
            if (V(vin) >= 0.8486328125) code = code + 1;
            if (V(vin) >= 0.8505859375) code = code + 1;
            if (V(vin) >= 0.8564453125) code = code + 1;
            if (V(vin) >= 0.8583984375) code = code + 1;
            if (V(vin) >= 0.8642578125) code = code + 1;
            if (V(vin) >= 0.8662109375) code = code + 1;
            if (V(vin) >= 0.8720703125) code = code + 1;
            if (V(vin) >= 0.8740234375) code = code + 1;
            if (V(vin) >= 0.8798828125) code = code + 1;
            if (V(vin) >= 0.8818359375) code = code + 1;
            if (V(vin) >= 0.8876953125) code = code + 1;
            if (V(vin) >= 0.8896484375) code = code + 1;
            if (V(vin) >= 0.8955078125) code = code + 1;
            if (V(vin) >= 0.8974609375) code = code + 1;
            if (V(vin) >= 0.9033203125) code = code + 1;
            if (V(vin) >= 0.9052734375) code = code + 1;
            if (V(vin) >= 0.9111328125) code = code + 1;
            if (V(vin) >= 0.9130859375) code = code + 1;
            if (V(vin) >= 0.9189453125) code = code + 1;
            if (V(vin) >= 0.9208984375) code = code + 1;
            if (V(vin) >= 0.9267578125) code = code + 1;
            if (V(vin) >= 0.9287109375) code = code + 1;
            if (V(vin) >= 0.9345703125) code = code + 1;
            if (V(vin) >= 0.9365234375) code = code + 1;
            if (V(vin) >= 0.9423828125) code = code + 1;
            if (V(vin) >= 0.9443359375) code = code + 1;
            if (V(vin) >= 0.9501953125) code = code + 1;
            if (V(vin) >= 0.9521484375) code = code + 1;
            if (V(vin) >= 0.9580078125) code = code + 1;
            if (V(vin) >= 0.9599609375) code = code + 1;
            if (V(vin) >= 0.9658203125) code = code + 1;
            if (V(vin) >= 0.9677734375) code = code + 1;
            if (V(vin) >= 0.9736328125) code = code + 1;
            if (V(vin) >= 0.9755859375) code = code + 1;
            if (V(vin) >= 0.9814453125) code = code + 1;
            if (V(vin) >= 0.9833984375) code = code + 1;
            if (V(vin) >= 0.9892578125) code = code + 1;
            if (V(vin) >= 0.9912109375) code = code + 1;
            if (V(vin) >= 0.9970703125) code = code + 1;
    end
        V(dout[0]) <+ transition((code >> 0) & 1, 1.9999999999999999e-07, 1n, 1n);
        V(dout[1]) <+ transition((code >> 1) & 1, 1.9999999999999999e-07, 1n, 1n);
        V(dout[2]) <+ transition((code >> 2) & 1, 1.9999999999999999e-07, 1n, 1n);
        V(dout[3]) <+ transition((code >> 3) & 1, 1.9999999999999999e-07, 1n, 1n);
        V(dout[4]) <+ transition((code >> 4) & 1, 1.9999999999999999e-07, 1n, 1n);
        V(dout[5]) <+ transition((code >> 5) & 1, 1.9999999999999999e-07, 1n, 1n);
        V(dout[6]) <+ transition((code >> 6) & 1, 1.9999999999999999e-07, 1n, 1n);
        V(dout[7]) <+ transition((code >> 7) & 1, 1.9999999999999999e-07, 1n, 1n);
end
endmodule
