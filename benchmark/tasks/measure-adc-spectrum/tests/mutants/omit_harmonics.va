`include "constants.vams"
`include "disciplines.vams"
module dut(code,clk,sndr,sfdr,dc);
inout code,clk,sndr,sfdr,dc;electrical code,clk,sndr,sfdr,dc;
parameter integer tone_bin=5;
real cs[0:32],ss[0:32],x,p,fund,spurious,noise,sum,out_sndr,out_sfdr,out_dc;
integer n,k;
analog begin
 @(initial_step)begin n=0;sum=0;out_sndr=0;out_sfdr=0;out_dc=0;for(k=0;k<=32;k=k+1)begin cs[k]=0;ss[k]=0;end end
 @(cross(V(clk)-0.5,+1))begin
  if(n<64)begin
   x=V(code);sum=sum+x;
   for(k=0;k<=32;k=k+1)begin cs[k]=cs[k]+x*cos(2*3.1415926535897932384626433832795*k*n/64.0);ss[k]=ss[k]+x*sin(2*3.1415926535897932384626433832795*k*n/64.0);end
   n=n+1;
   if(n==64)begin
    fund=2*(cs[tone_bin]*cs[tone_bin]+ss[tone_bin]*ss[tone_bin])/4096;
    noise=0;spurious=0;
    for(k=1;k<=32;k=k+1)if(k!=tone_bin && k!=2*tone_bin && k!=3*tone_bin)begin
     p=2*(cs[k]*cs[k]+ss[k]*ss[k])/4096;if(k==32)p=p/2;
     noise=noise+p;if(p>spurious)spurious=p;
    end
    out_sndr=10*ln(fund/noise)/ln(10);out_sfdr=10*ln(fund/spurious)/ln(10);out_dc=sum/64;
   end
  end
 end
 V(sndr)<+out_sndr;V(sfdr)<+out_sfdr;V(dc)<+out_dc;
end
endmodule
