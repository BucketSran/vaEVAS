simulator lang=spectre
global 0
ahdl_include "../dut.va"
Vclk (clk 0) vsource type=pwl wave=[0 0 1.98e-09 0 2.02e-09 1 3.48e-09 1 3.52e-09 0 5.98e-09 0 6.02e-09 1 7.48e-09 1 7.52e-09 0 9.98e-09 0 1.002e-08 1 1.148e-08 1 1.152e-08 0 1.398e-08 0 1.402e-08 1 1.548e-08 1 1.552e-08 0 1.798e-08 0 1.802e-08 1 1.948e-08 1 1.952e-08 0 2.198e-08 0 2.202e-08 1 2.348e-08 1 2.352e-08 0 2.598e-08 0 2.602e-08 1 2.748e-08 1 2.752e-08 0 2.998e-08 0 3.002e-08 1 3.148e-08 1 3.152e-08 0 3.398e-08 0 3.402e-08 1 3.548e-08 1 3.552e-08 0 3.798e-08 0 3.802e-08 1 3.948e-08 1 3.952e-08 0 4.198e-08 0 4.202e-08 1 4.348e-08 1 4.352e-08 0 4.598e-08 0 4.602e-08 1 4.748e-08 1 4.752e-08 0 4.998e-08 0 5.002e-08 1 5.148e-08 1 5.152e-08 0]
Vstart (start 0) vsource type=pwl wave=[0 0 9.8e-10 0 1.02e-09 1 1.48e-09 1 1.52e-09 0 1.698e-08 0 1.702e-08 1 1.748e-08 1 1.752e-08 0 3.298e-08 0 3.302e-08 1 3.348e-08 1 3.352e-08 0]
Vrst (rst 0) vsource type=pwl wave=[0 0 1.428e-08 0 1.432e-08 1 1.528e-08 1 1.532e-08 0]
Vvin (vin 0) vsource type=pwl wave=[0 0.55 1.6e-08 0.55 1.604e-08 0.35 3.2e-08 0.35 3.204e-08 0.72]
ahdl_include "adc_compare.va"
XCMP (vin trial cmp) adc_compare
XDUT (clk start rst cmp d3 d2 d1 d0 trial busy valid) sar_controller tvalid=8e-10
simulatorOptions options reltol=1e-6 vabstol=1e-9
tran tran stop=5.2e-08 maxstep=2e-11
save clk start rst cmp d3 d2 d1 d0 trial busy valid
save vin
