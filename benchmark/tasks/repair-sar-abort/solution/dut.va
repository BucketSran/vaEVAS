`include "constants.vams"
`include "disciplines.vams"
module sar_controller(clk,start,rst,cmp,d3,d2,d1,d0,trial,busy,valid);
input clk,start,rst,cmp;output d3,d2,d1,d0,trial,busy,valid;
electrical clk,start,rst,cmp,d3,d2,d1,d0,trial,busy,valid;
parameter real vth=0.5,tr=50p,tvalid=0.8n;
integer active,pending,position,working,result,weight,j,done;
real dac,next_publish;
analog begin
 @(initial_step)begin done=0;active=0;pending=0;position=3;working=0;result=0;dac=0;next_publish=1e30;end
 @(cross(V(rst)-vth,+1))begin done=0;active=0;pending=0;working=0;result=0;dac=0;next_publish=1e30;end
 @(cross(V(start)-vth,+1))if(V(rst)<vth && active==0)begin done=0;active=1;pending=0;position=3;working=0;result=0;dac=0.5;next_publish=1e30;end
 @(cross(V(clk)-vth,+1))if(active && !pending && V(rst)<vth)begin
  weight=1;for(j=0;j<position;j=j+1)weight=weight*2;
  if(V(cmp)>vth)working=working+weight;
  if(position==0)begin pending=1;dac=working/16.0;next_publish=$abstime+tvalid;end
  else begin position=position-1;weight=weight/2;dac=(working+weight)/16.0;end
 end
 @(timer(next_publish))if(active && pending && V(rst)<vth)begin result=working;done=1;active=0;pending=0;next_publish=1e30;end
 V(d3)<+transition((result>=8)?1:0,0,tr,tr);
 V(d2)<+transition(((result/4)%2)?1:0,0,tr,tr);
 V(d1)<+transition(((result/2)%2)?1:0,0,tr,tr);
 V(d0)<+transition((result%2)?1:0,0,tr,tr);
 V(trial)<+transition(dac,0,tr,tr);
 V(busy)<+transition(active,0,tr,tr);V(valid)<+transition(done?1:0,0,tr,tr);
end
endmodule
