simulator lang=spectre
global 0
ahdl_include "/work/dut.va"
VRX (rx 0) vsource type=pwl wave=[0 1 0.000303713 1 0.00030372299999999999 0 0.0003054491111111111 0 0.00030545911111111109 1 0.001003716 1 0.0010037259999999999 0 0.0010125701666666665 0 0.0010125801666666665 1 0.0010214243333333333 1 0.0010214343333333333 0 0.0010302785000000001 0 0.0010302885 1 0.0010391326666666667 1 0.0010391426666666666 0 0.001056841 0 0.0010568509999999999 1 0.0010656951666666668 1 0.0010657051666666667 0 0.0010745493333333333 0 0.0010745593333333333 1 0.011020946 1 0.011020956 0 0.01103795988888889 0 0.011037969888888889 1 0.011046466833333334 1 0.011046476833333334 0 0.011071987666666666 0 0.011071997666666666 1 0.021038175999999999 1 0.021038186 0 0.021047030166666664 0 0.021047040166666666 1 0.021091301 1 0.021091311000000001 0 0.0211178635 0 0.021117873500000002 1 0.031055406000000001 1 0.031055416000000002 0 0.031080926833333335 0 0.031080936833333336 1 0.031106447666666669 1 0.03110645766666667 0 0.031114954611111113 0 0.031114964611111115 1 0.031123461555555555 1 0.031123471555555556 0 0.031131968499999999 0 0.031131978500000001 1 0.041072636000000003 1 0.041072646000000004 0 0.041081490166666672 0 0.041081500166666673 1 0.041090344333333334 1 0.041090354333333336 0 0.041108052666666672 0 0.041108062666666674 1 0.041125761000000004 1 0.041125771000000005 0 0.041143469333333335 0 0.041143479333333337 1 0.051089866000000005 1 0.051089876000000006 0 0.051106879888888894 0 0.051106889888888896 1 0.051123893777777783 1 0.051123903777777785 0 0.051132400722222228 0 0.05113241072222223 1 0.051140907666666673 1 0.051140917666666674 0 0.051149414611111117 0 0.051149424611111119 1 0.061107096 1 0.061107106000000001 0 0.061115950166666669 0 0.06111596016666667 1 0.0611336585 1 0.061133668500000002 0 0.061151366833333332 0 0.061151376833333333 1 0.061160221000000001 1 0.061160231000000002 0 0.061186783500000001 0 0.061186793500000003 1 0.071124326000000002 1 0.071124335999999996 0 0.071166860722222225 0 0.07116687072222222 1 0.07117536766666667 1 0.071175377666666664 0 0.071183874611111114 0 0.071183884611111109 1 0.071192381555555559 1 0.071192391555555554 0 0.071200888500000004 0 0.071200898499999998 1 0.081141556000000004 1 0.081141565999999998 0 0.081150410166666673 0 0.081150420166666667 1 0.081159264333333342 1 0.081159274333333337 0 0.081168118499999997 0 0.081168128499999992 1 0.081185826833333335 1 0.08118583683333333 0 0.081212389333333343 0 0.081212399333333338 1 0.091158786000000006 1 0.091158796 0 0.091175799888888895 0 0.09117580988888889 1 0.09118430683333334 1 0.091184316833333334 0 0.091192813777777784 0 0.091192823777777779 1 0.091201320722222229 1 0.091201330722222224 0 0.091218334611111118 0 0.091218344611111113 1 0.10000000000000001 1]
VRESET (reset 0) vsource type=pwl wave=[0 0 0.10000000000000001 0]
DUT (rx reset busy valid error data shift) uart_receiver bit_period=8.680555555555556e-06
simulatorOptions options reltol=1e-6 vabstol=1e-9 iabstol=1e-14
tran tran stop=0.1 errpreset=conservative
save rx reset busy valid error data shift
