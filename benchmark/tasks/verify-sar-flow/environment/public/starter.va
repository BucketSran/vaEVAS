`include "constants.vams"
`include "disciplines.vams"
module dut(vin,start,rst,code,done,verdict);
inout vin,start,rst,code,done,verdict; electrical vin,start,rst,code,done,verdict;
// TODO: implement the required experiment and result ports.
endmodule
