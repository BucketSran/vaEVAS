simulator lang=spectre
global 0
ahdl_include "../dut.va"
Vclk (clk 0) vsource type=pwl wave=[0 0 1.98e-09 0 2.02e-09 1 3.98e-09 1 4.02e-09 0 5.98e-09 0 6.02e-09 1 7.98e-09 1 8.02e-09 0 9.98e-09 0 1.002e-08 1 1.198e-08 1 1.202e-08 0 1.398e-08 0 1.402e-08 1 1.598e-08 1 1.602e-08 0 1.798e-08 0 1.802e-08 1 1.998e-08 1 2.002e-08 0 2.198e-08 0 2.202e-08 1 2.398e-08 1 2.402e-08 0 2.598e-08 0 2.602e-08 1 2.798e-08 1 2.802e-08 0 2.998e-08 0 3.002e-08 1 3.198e-08 1 3.202e-08 0]
Vdata (data 0) vsource type=pwl wave=[0 0 2.73e-09 0 2.77e-09 1 4.73e-09 1 4.77e-09 0 6.73e-09 0 6.77e-09 1 8.73e-09 1 8.77e-09 0 1.073e-08 0 1.077e-08 1 1.473e-08 1 1.477e-08 0 1.873e-08 0 1.877e-08 1 2.273e-08 1 2.277e-08 0 2.673e-08 0 2.677e-08 1]
Vretimed (retimed 0) vsource type=pwl wave=[0 0 6.38e-09 0 6.42e-09 1 1.038e-08 1 1.042e-08 0 1.438e-08 0 1.442e-08 1 2.238e-08 1 2.242e-08 0 2.638e-08 0 2.642e-08 1]
XDUT (data clk retimed up down) cdr_phase_detector
simulatorOptions options reltol=1e-6 vabstol=1e-9
tran tran stop=3.6e-08 maxstep=2e-11
save data clk retimed up down
