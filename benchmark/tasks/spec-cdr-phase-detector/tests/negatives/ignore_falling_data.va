`include "constants.vams"
`include "disciplines.vams"
module cdr_phase_detector(data,clk,retimed,up,down);
input data,clk,retimed;output up,down;electrical data,clk,retimed,up,down;
parameter real vth=0.5,tr=50p;
real u,d;
analog begin
 @(initial_step) begin u=0;d=0;end
 @(cross(V(clk)-vth,0)) begin u=0;d=0;end
 @(cross(V(data)-vth,+1)) begin
  u=0;d=0;
  if(V(clk)>vth && V(retimed)<vth) u=1;
  else if(V(clk)<vth && V(retimed)>vth) d=1;
 end
 V(up)<+transition(u,0,tr,tr);V(down)<+transition(d,0,tr,tr);
end
endmodule
