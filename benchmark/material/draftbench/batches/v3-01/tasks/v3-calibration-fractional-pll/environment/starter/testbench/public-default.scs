simulator lang=spectre
global 0
ahdl_include "healthy.va"
ahdl_include "/app/circuit.va"
VR(ref 0) vsource type=pulse val0=0 val1=0.9 period=100n width=49n rise=100p fall=100p delay=10n
Vreset(rst 0) vsource type=pwl wave=[0 0.9 2e-07 0.9 2.01e-07 0 0.0001 0 0.000100001 0.9 0.0001003 0.9 0.000100301 0 0.0002 0]
VN(n 0) vsource type=pwl wave=[0 3 5e-05 3 5.0001e-05 4 0.0002 4]
VF(frac 0) vsource type=pwl wave=[0 0 2.5e-05 0 2.5001e-05 0.25 7.5e-05 0.25 7.5001e-05 0 0.000125 0 0.000125001 0.5 0.0002 0.5]
XO(tune rst dco) healthy_dco frequency_step=2000000
X(ref rst n frac dco fb tune lock) fractional_pll
tran tran stop=200u maxstep=2n errpreset=conservative
save ref rst n frac dco fb tune lock
