`include "constants.vams"
`include "disciplines.vams"

module ctle(u,y);
inout u,y;
electrical u,y;
// TODO: implement the public contract.
endmodule
