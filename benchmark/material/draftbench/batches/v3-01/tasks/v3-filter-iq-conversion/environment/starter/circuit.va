`include "constants.vams"
`include "disciplines.vams"

module iq_mixer(i,q,lc,ls,rf,en,up,di,dq);
inout i,q,lc,ls,rf,en,up,di,dq;
electrical i,q,lc,ls,rf,en,up,di,dq;
// TODO: implement the public contract.
endmodule
