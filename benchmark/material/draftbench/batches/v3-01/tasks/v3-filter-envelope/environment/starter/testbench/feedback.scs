simulator lang=spectre
ahdl_include "/app/circuit.va"
Vi (i 0) vsource type=pwl wave=[0 0.1 0.001 0.1 0.001001 0.4 0.003 0.4 0.003001 0.05 0.008 0.05]
Vq (q 0) vsource type=pwl wave=[0 0.12 0.002 0.12 0.002001 -0.2 0.007 -0.2]
Ve (en 0) vsource type=pwl wave=[0 1 0.004 1 0.004001 0 0.006 0 0.006001 1]
Vr (reset 0) vsource type=pwl wave=[0 0 0.0068 0 0.006801 1 0.007 1 0.007001 0]
X (i q en reset env) envelope bandwidth=150 initval=0.0
tran tran stop=0.009 maxstep=1e-06 errpreset=conservative
save i q en reset env
