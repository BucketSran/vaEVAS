simulator lang=spectre
global 0
ahdl_include "healthy.va"
ahdl_include "dut.va"
VI(inp 0) vsource type=pwl wave=[0 0 4e-05 0 4.5e-05 -0.06 6.5e-05 -0.06 7e-05 0.04 9.5e-05 0.04 9.9e-05 0 0.0001 0 0.00014 0 0.000145 0.06 0.000165 0.06 0.00017 -0.04 0.000195 -0.04 0.000199 0 0.0002 0 0.00024 0 0.000245 -0.06 0.000265 -0.06 0.00027 0.04 0.000295 0.04 0.000299 0 0.0003 0 0.00034 0 0.000345 0.06 0.000365 0.06 0.00037 -0.04 0.000395 -0.04 0.000399 0 0.0004 0 0.00044 0 0.000445 -0.06 0.000465 -0.06 0.00047 0.04 0.000495 0.04 0.000499 0 0.0005 0 0.00054 0 0.000545 0.06 0.000565 0.06 0.00057 -0.04 0.000595 -0.04 0.000599 0 0.0006 0 0.00064 0 0.000645 -0.06 0.000665 -0.06 0.00067 0.04 0.000695 0.04 0.000699 0 0.0007 0 0.00074 0 0.000745 0.06 0.000765 0.06 0.00077 -0.04 0.000795 -0.04 0.000799 0 0.0008 0 0.00084 0 0.000845 -0.06 0.000865 -0.06 0.00087 0.04 0.000895 0.04 0.000899 0 0.0009 0 0.00094 0 0.000945 0.06 0.000965 0.06 0.00097 -0.04 0.000995 -0.04 0.000999 0 0.001 0 0.00104 0 0.001045 -0.06 0.001065 -0.06 0.00107 0.04 0.001095 0.04 0.001099 0]
VN(inn 0) vsource dc=0
VC(cal 0) vsource type=pwl wave=[0 0.9 3.9e-05 0.9 4e-05 0 9.9e-05 0 0.0001 0.9 0.000139 0.9 0.00014 0 0.000199 0 0.0002 0.9 0.000239 0.9 0.00024 0 0.000299 0 0.0003 0.9 0.000339 0.9 0.00034 0 0.000399 0 0.0004 0.9 0.000439 0.9 0.00044 0 0.000499 0 0.0005 0.9 0.000539 0.9 0.00054 0 0.000599 0 0.0006 0.9 0.000639 0.9 0.00064 0 0.000699 0 0.0007 0.9 0.000739 0.9 0.00074 0 0.000799 0 0.0008 0.9 0.000839 0.9 0.00084 0 0.000899 0 0.0009 0.9 0.000939 0.9 0.00094 0 0.000999 0 0.001 0.9 0.001039 0.9 0.00104 0 0.001099 0]
VE(enable 0) vsource type=pwl wave=[0 0.9 0.00055 0.9 0.000551 0 0.00065 0 0.000651 0.9 0.001 0.9]
VR(rst 0) vsource type=pwl wave=[0 0 0.00075 0 0.000751 0.9 0.00076 0.9 0.000761 0 0.001 0]
VO(offset 0) vsource type=pwl wave=[0 0.02 0.001 0.02]
VM(cmoffset 0) vsource type=pwl wave=[0 0.02 0.0002 0.07 0.0003 -0.07 0.0004 -0.07 0.00041 0.5 0.00048 0.5 0.00049 0.04 0.0006 -0.055 0.0007 -0.055 0.0008 0.07 0.001 0.025]
XF(inp inn offset cmoffset code outp outn) healthy_front mode=1 actuator=0.8
XC(outp outn cal enable rst code) calibration_controller mode=1
tran tran stop=1m maxstep=500n errpreset=conservative
save inp inn offset cmoffset cal enable rst code outp outn
