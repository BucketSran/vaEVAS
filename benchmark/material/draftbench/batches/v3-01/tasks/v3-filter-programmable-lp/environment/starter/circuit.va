`include "constants.vams"
`include "disciplines.vams"

module programmable_lp(u,code,reset,y);
inout u,code,reset,y;
electrical u,code,reset,y;
// TODO: implement the public contract.
endmodule
