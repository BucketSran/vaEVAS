`include "disciplines.vams"
module ota(vin,enable,vout);
input vin,enable; output vout; electrical vin,enable,vout; electrical q;
parameter real tau=20n, positive=10e6, negative=6e6, gain=0.98, low=0.1, high=1.4;
real target,rate;
analog begin
// Implement the public contract.
end
endmodule
