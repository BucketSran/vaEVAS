simulator lang=spectre
global 0

ahdl_include "/app/circuit.va"

V_IN_CLK (in_clk 0) vsource type=pwl wave=[0 0 190p 0 210p 0.9 390p 0.9 410p 0 990p 0 1010p 0.9 1290p 0.9 1310p 0 1690p 0 1710p 0.9 1990p 0.9 2010p 0 2390p 0 2410p 0.9 2490p 0.9 2510p 0 2890p 0 2910p 0.9 2950p 0.9 2970p 0 3130p 0 3150p 0.9 3190p 0.9 3210p 0 3590p 0 3610p 0.9 3790p 0.9 3810p 0 3990p 0 4010p 0.9 4290p 0.9 4310p 0 4690p 0 4710p 0.9 4790p 0.9 4810p 0 5190p 0 5210p 0.9 5290p 0.9 5310p 0 5800p 0]
V_LOAD (load 0) vsource type=pwl wave=[0 0 590p 0 610p 0.9 790p 0.9 810p 0 1490p 0 1510p 0.9 1550p 0.9 1570p 0 1830p 0 1850p 0.9 1890p 0.9 1910p 0 2690p 0 2710p 0.9 2750p 0.9 2770p 0 3030p 0 3050p 0.9 3070p 0.9 3090p 0 3587p 0 3607p 0.9 3690p 0.9 3710p 0 4990p 0 5010p 0.9 5050p 0.9 5070p 0 5800p 0]
V_RST (rst 0) vsource type=pwl wave=[0 0 4370p 0 4390p 0.9 4510p 0.9 4530p 0 5240p 0 5260p 0.9 5340p 0.9 5360p 0 5800p 0]
V_CODE_5 (code_5 0) vsource type=pwl wave=[0 0 690p 0 710p 0.9 1790p 0.9 1810p 0 2590p 0 2610p 0.9 2990p 0.9 3010p 0 3390p 0 3410p 0.9 5800p 0.9]
V_CODE_4 (code_4 0) vsource type=pwl wave=[0 0 690p 0 710p 0.9 1790p 0.9 1810p 0 2590p 0 2610p 0.9 3390p 0.9 3410p 0 4890p 0 4910p 0.9 5800p 0.9]
V_CODE_3 (code_3 0) vsource type=pwl wave=[0 0 490p 0 510p 0.9 690p 0.9 710p 0 2590p 0 2610p 0.9 2990p 0.9 3010p 0 3390p 0 3410p 0.9 5800p 0.9]
V_CODE_2 (code_2 0) vsource type=pwl wave=[0 0 1790p 0 1810p 0.9 5800p 0.9]
V_CODE_1 (code_1 0) vsource type=pwl wave=[0 0 490p 0 510p 0.9 1790p 0.9 1810p 0 2590p 0 2610p 0.9 2990p 0.9 3010p 0 5800p 0]
V_CODE_0 (code_0 0) vsource type=pwl wave=[0 0 1790p 0 1810p 0.9 2990p 0.9 3010p 0 3390p 0 3410p 0.9 4890p 0.9 4910p 0 5800p 0]
XDUT (in_clk load rst code_5 code_4 code_3 code_2 code_1 code_0 out_clk) programmable_delay_cell

simulatorOptions options reltol=1e-6 vabstol=1e-8 iabstol=1e-12
tran tran stop=5800p maxstep=2p strobeperiod=2p errpreset=moderate strobeoutput=strobeonly
save in_clk load rst code_5 code_4 code_3 code_2 code_1 code_0 out_clk
