simulator lang=spectre
global 0

ahdl_include "/app/circuit.va"

Vvin (vin 0) vsource type=pwl wave=[0 0.9 34.5n 0.9 35.5n 0.2 74.5n 0.2 75.5n 0.5 94.5n 0.5 95.5n -0.3 114.5n -0.3 115.5n 0.75 139.5n 0.75 140.5n 1.1 154.5n 1.1 155.5n 0.6 204.5n 0.6 205.5n 0.95 224.5n 0.95 225.5n 0.7 259.5n 0.7 260.5n 0.35 274.5n 0.35 275.5n 0.55 300n 0.55]
Vclk (clk 0) vsource type=pwl wave=[0 0 9.95n 0 10.05n 0.9 15.95n 0.9 16.05n 0 29.95n 0 30.05n 0.9 35.95n 0.9 36.05n 0 49.95n 0 50.05n 0.9 55.95n 0.9 56.05n 0 69.95n 0 70.05n 0.9 75.95n 0.9 76.05n 0 89.95n 0 90.05n 0.9 95.95n 0.9 96.05n 0 109.95n 0 110.05n 0.9 115.95n 0.9 116.05n 0 129.95n 0 130.05n 0.9 135.95n 0.9 136.05n 0 149.95n 0 150.05n 0.9 155.95n 0.9 156.05n 0 169.95n 0 170.05n 0.9 175.95n 0.9 176.05n 0 189.95n 0 190.05n 0.9 195.95n 0.9 196.05n 0 209.95n 0 210.05n 0.9 215.95n 0.9 216.05n 0 229.95n 0 230.05n 0.9 235.95n 0.9 236.05n 0 249.95n 0 250.05n 0.9 255.95n 0.9 256.05n 0 269.95n 0 270.05n 0.9 275.95n 0.9 276.05n 0 289.95n 0 290.05n 0.9 295.95n 0.9 296.05n 0 300n 0]
Vmode (mode 0) vsource type=pwl wave=[0 0 57.95n 0 58.05n 0.9 78.95n 0.9 79.05n 0 97.95n 0 98.05n 0.9 137.95n 0.9 138.05n 0 254.95n 0 255.05n 0.9 300n 0.9]
Vrst (rst 0) vsource type=pwl wave=[0 0.9 14.95n 0.9 15.05n 0 174.95n 0 175.05n 0.9 184.95n 0.9 185.05n 0 194.95n 0 195.05n 0.9 199.95n 0.9 200.05n 0 210.95n 0 211.05n 0.9 234.95n 0.9 235.05n 0 300n 0]

XDUT (vin clk mode rst out metric) slew_envelope_tracker

tran tran stop=300n maxstep=50p strobeperiod=50p
save vin clk mode rst out metric
