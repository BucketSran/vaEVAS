simulator lang=spectre
global 0

ahdl_include "/app/circuit.va"

Vvin (vin 0) vsource type=pwl wave=[0 0.3 7n 0.3 7.1n 0.30375 17n 0.30375 17.1n 0.1 27n 0.1 27.1n 0.590625 37n 0.590625 37.1n 0.5 47n 0.5 47.1n 0.2 57n 0.2 57.1n 0.073125 67n 0.073125 67.1n 0.82125 77n 0.82125 77.1n 0.405 87n 0.405 87.1n 0.478125 97n 0.478125 97.1n 0.22 107n 0.22 107.1n 0.8 117n 0.8 117.1n 0.68 127n 0.68 127.1n 0.55 137n 0.55 137.1n 0.23 147n 0.23 147.1n 0.67 157n 0.67 157.1n 0.9 167n 0.9 167.1n 0.534375 177n 0.534375 177.1n 0.140625 187n 0.140625 187.1n 0.759375 197n 0.759375 197.1n -0.12 207n -0.12 207.1n 0.365625 217n 0.365625 217.1n 0.1 227n 0.1 227.1n 0.75 237n 0.75 237.1n 0.5 247n 0.5 247.1n 1.05 257n 1.05 257.1n 0.85 267n 0.85 267.1n 0.05 277n 0.05 277.1n 0.62 287n 0.62 287.1n 0.445 297n 0.445 297.1n 0.455 307n 0.455 307.1n 0.8 317n 0.8 317.1n 0.129375 327n 0.129375 327.1n 0.7425 337n 0.7425 337.1n 0.264375 347n 0.264375 347.1n 0.33 357n 0.33 357.1n 0.9 377n 0.9 377.1n 0.47 387n 0.47 387.1n 0.6 402n 0.6]
Vclk (clk 0) vsource type=pwl wave=[0 0 5n 0 5.05n 0.5 5.1n 0.9 10n 0.9 10.05n 0.4 10.1n 0 15n 0 15.05n 0.5 15.1n 0.9 20n 0.9 20.05n 0.4 20.1n 0 25n 0 25.05n 0.5 25.1n 0.9 30n 0.9 30.05n 0.4 30.1n 0 35n 0 35.05n 0.5 35.1n 0.9 40n 0.9 40.05n 0.4 40.1n 0 45n 0 45.05n 0.5 45.1n 0.9 50n 0.9 50.05n 0.4 50.1n 0 55n 0 55.05n 0.5 55.1n 0.9 60n 0.9 60.05n 0.4 60.1n 0 65n 0 65.05n 0.5 65.1n 0.9 70n 0.9 70.05n 0.4 70.1n 0 75n 0 75.05n 0.5 75.1n 0.9 80n 0.9 80.05n 0.4 80.1n 0 85n 0 85.05n 0.5 85.1n 0.9 90n 0.9 90.05n 0.4 90.1n 0 95n 0 95.05n 0.5 95.1n 0.9 100n 0.9 100.05n 0.4 100.1n 0 105n 0 105.05n 0.5 105.1n 0.9 110n 0.9 110.05n 0.4 110.1n 0 115n 0 115.05n 0.5 115.1n 0.9 120n 0.9 120.05n 0.4 120.1n 0 125n 0 125.05n 0.5 125.1n 0.9 130n 0.9 130.05n 0.4 130.1n 0 135n 0 135.05n 0.5 135.1n 0.9 140n 0.9 140.05n 0.4 140.1n 0 145n 0 145.05n 0.5 145.1n 0.9 150n 0.9 150.05n 0.4 150.1n 0 155n 0 155.05n 0.5 155.1n 0.9 160n 0.9 160.05n 0.4 160.1n 0 165n 0 165.05n 0.5 165.1n 0.9 170n 0.9 170.05n 0.4 170.1n 0 175n 0 175.05n 0.5 175.1n 0.9 180n 0.9 180.05n 0.4 180.1n 0 185n 0 185.05n 0.5 185.1n 0.9 190n 0.9 190.05n 0.4 190.1n 0 195n 0 195.05n 0.5 195.1n 0.9 200n 0.9 200.05n 0.4 200.1n 0 205n 0 205.05n 0.5 205.1n 0.9 210n 0.9 210.05n 0.4 210.1n 0 215n 0 215.05n 0.5 215.1n 0.9 220n 0.9 220.05n 0.4 220.1n 0 225n 0 225.05n 0.5 225.1n 0.9 230n 0.9 230.05n 0.4 230.1n 0 235n 0 235.05n 0.5 235.1n 0.9 240n 0.9 240.05n 0.4 240.1n 0 245n 0 245.05n 0.5 245.1n 0.9 250n 0.9 250.05n 0.4 250.1n 0 255n 0 255.05n 0.5 255.1n 0.9 260n 0.9 260.05n 0.4 260.1n 0 265n 0 265.05n 0.5 265.1n 0.9 270n 0.9 270.05n 0.4 270.1n 0 275n 0 275.05n 0.5 275.1n 0.9 280n 0.9 280.05n 0.4 280.1n 0 285n 0 285.05n 0.5 285.1n 0.9 290n 0.9 290.05n 0.4 290.1n 0 295n 0 295.05n 0.5 295.1n 0.9 300n 0.9 300.05n 0.4 300.1n 0 305n 0 305.05n 0.5 305.1n 0.9 310n 0.9 310.05n 0.4 310.1n 0 315n 0 315.05n 0.5 315.1n 0.9 320n 0.9 320.05n 0.4 320.1n 0 325n 0 325.05n 0.5 325.1n 0.9 330n 0.9 330.05n 0.4 330.1n 0 335n 0 335.05n 0.5 335.1n 0.9 340n 0.9 340.05n 0.4 340.1n 0 345n 0 345.05n 0.5 345.1n 0.9 350n 0.9 350.05n 0.4 350.1n 0 355n 0 355.05n 0.5 355.1n 0.9 360n 0.9 360.05n 0.4 360.1n 0 365n 0 365.05n 0.5 365.1n 0.9 370n 0.9 370.05n 0.4 370.1n 0 375n 0 375.05n 0.5 375.1n 0.9 380n 0.9 380.05n 0.4 380.1n 0 385n 0 385.05n 0.5 385.1n 0.9 390n 0.9 390.05n 0.4 390.1n 0 395n 0 395.05n 0.5 395.1n 0.9 400n 0.9 400.05n 0.4 400.1n 0 402n 0]
Vrst (rst 0) vsource type=pwl wave=[0 0.9 12n 0.9 12.05n 0.4 12.1n 0 198n 0 198.05n 0.5 198.1n 0.9 201n 0.9 201.05n 0.4 201.1n 0 402n 0]
Vvalid (valid_i 0) vsource type=pwl wave=[0 0 4n 0 4.05n 0.5 4.1n 0.9 20n 0.9 20.05n 0.4 20.1n 0 25.3n 0 25.35n 0.5 25.4n 0.9 35.3n 0.9 35.35n 0.4 35.4n 0 64.7n 0 64.75n 0.5 64.8n 0.9 114.7n 0.9 114.75n 0.4 114.8n 0 120n 0 120.05n 0.5 120.1n 0.9 130n 0.9 130.05n 0.4 130.1n 0 140n 0 140.05n 0.5 140.1n 0.9 160n 0.9 160.05n 0.4 160.1n 0 170n 0 170.05n 0.5 170.1n 0.9 220n 0.9 220.05n 0.4 220.1n 0 250n 0 250.05n 0.5 250.1n 0.9 260n 0.9 260.05n 0.4 260.1n 0 290n 0 290.05n 0.5 290.1n 0.9 310n 0.9 310.05n 0.4 310.1n 0 320n 0 320.05n 0.5 320.1n 0.9 350n 0.9 350.05n 0.4 350.1n 0 370n 0 370.05n 0.5 370.1n 0.9 380n 0.9 380.05n 0.4 380.1n 0 402n 0]

XDUT (vin clk rst valid_i code_3 code_2 code_1 code_0 valid_o residue_dbg) pipeline_adc_two_stage

simulatorOptions options reltol=1e-6 vabstol=1e-8 iabstol=1e-12
tran tran stop=402n maxstep=50p strobeperiod=50p errpreset=moderate strobeoutput=strobeonly
save vin clk rst valid_i code_3 code_2 code_1 code_0 valid_o residue_dbg
