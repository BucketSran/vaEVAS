simulator lang=spectre
global 0

ahdl_include "/app/circuit.va"

Vvin (vin 0) vsource type=pwl wave=[0 0.3 22.05n 0.3 22.15n 0.6 30.05n 0.6 30.15n 0.2 62.05n 0.2 62.15n 0.455 70.05n 0.455 70.15n 0.7 110.05n 0.7 110.15n 0.2 118.05n 0.2 118.15n 0.78 142.05n 0.78 142.15n 0.05 182.05n 0.05 182.15n -0.15 190.05n -0.15 190.15n 0.4 230.05n 0.4 230.15n 1.05 238.05n 1.05 238.15n 0.3 294.05n 0.3 294.15n 0.33 302.05n 0.33 302.15n 0.9 334.05n 0.9 334.15n 0.5675 342.05n 0.5675 342.15n 0.02 377.05n 0.02 377.15n 0.1 390.05n 0.1 390.15n 0.6 430.05n 0.6 430.15n 0.85 438.05n 0.85 438.15n 0.25 476n 0.25]
Vclk (clk 0) vsource type=pwl wave=[0 0 4n 0 4.05n 0.5 4.1n 0.9 8n 0.9 8.05n 0.4 8.1n 0 12n 0 12.05n 0.5 12.1n 0.9 16n 0.9 16.05n 0.4 16.1n 0 20n 0 20.05n 0.5 20.1n 0.9 24n 0.9 24.05n 0.4 24.1n 0 28n 0 28.05n 0.5 28.1n 0.9 32n 0.9 32.05n 0.4 32.1n 0 36n 0 36.05n 0.5 36.1n 0.9 40n 0.9 40.05n 0.4 40.1n 0 44n 0 44.05n 0.5 44.1n 0.9 48n 0.9 48.05n 0.4 48.1n 0 52n 0 52.05n 0.5 52.1n 0.9 56n 0.9 56.05n 0.4 56.1n 0 60n 0 60.05n 0.5 60.1n 0.9 64n 0.9 64.05n 0.4 64.1n 0 68n 0 68.05n 0.5 68.1n 0.9 72n 0.9 72.05n 0.4 72.1n 0 76n 0 76.05n 0.5 76.1n 0.9 80n 0.9 80.05n 0.4 80.1n 0 84n 0 84.05n 0.5 84.1n 0.9 88n 0.9 88.05n 0.4 88.1n 0 92n 0 92.05n 0.5 92.1n 0.9 96n 0.9 96.05n 0.4 96.1n 0 100n 0 100.05n 0.5 100.1n 0.9 104n 0.9 104.05n 0.4 104.1n 0 108n 0 108.05n 0.5 108.1n 0.9 112n 0.9 112.05n 0.4 112.1n 0 116n 0 116.05n 0.5 116.1n 0.9 120n 0.9 120.05n 0.4 120.1n 0 124n 0 124.05n 0.5 124.1n 0.9 128n 0.9 128.05n 0.4 128.1n 0 132n 0 132.05n 0.5 132.1n 0.9 136n 0.9 136.05n 0.4 136.1n 0 140n 0 140.05n 0.5 140.1n 0.9 144n 0.9 144.05n 0.4 144.1n 0 148n 0 148.05n 0.5 148.1n 0.9 152n 0.9 152.05n 0.4 152.1n 0 156n 0 156.05n 0.5 156.1n 0.9 160n 0.9 160.05n 0.4 160.1n 0 164n 0 164.05n 0.5 164.1n 0.9 168n 0.9 168.05n 0.4 168.1n 0 172n 0 172.05n 0.5 172.1n 0.9 176n 0.9 176.05n 0.4 176.1n 0 180n 0 180.05n 0.5 180.1n 0.9 184n 0.9 184.05n 0.4 184.1n 0 188n 0 188.05n 0.5 188.1n 0.9 192n 0.9 192.05n 0.4 192.1n 0 196n 0 196.05n 0.5 196.1n 0.9 200n 0.9 200.05n 0.4 200.1n 0 204n 0 204.05n 0.5 204.1n 0.9 208n 0.9 208.05n 0.4 208.1n 0 212n 0 212.05n 0.5 212.1n 0.9 216n 0.9 216.05n 0.4 216.1n 0 220n 0 220.05n 0.5 220.1n 0.9 224n 0.9 224.05n 0.4 224.1n 0 228n 0 228.05n 0.5 228.1n 0.9 232n 0.9 232.05n 0.4 232.1n 0 236n 0 236.05n 0.5 236.1n 0.9 240n 0.9 240.05n 0.4 240.1n 0 244n 0 244.05n 0.5 244.1n 0.9 248n 0.9 248.05n 0.4 248.1n 0 252n 0 252.05n 0.5 252.1n 0.9 256n 0.9 256.05n 0.4 256.1n 0 260n 0 260.05n 0.5 260.1n 0.9 264n 0.9 264.05n 0.4 264.1n 0 268n 0 268.05n 0.5 268.1n 0.9 272n 0.9 272.05n 0.4 272.1n 0 276n 0 276.05n 0.5 276.1n 0.9 280n 0.9 280.05n 0.4 280.1n 0 284n 0 284.05n 0.5 284.1n 0.9 288n 0.9 288.05n 0.4 288.1n 0 292n 0 292.05n 0.5 292.1n 0.9 296n 0.9 296.05n 0.4 296.1n 0 300n 0 300.05n 0.5 300.1n 0.9 304n 0.9 304.05n 0.4 304.1n 0 308n 0 308.05n 0.5 308.1n 0.9 312n 0.9 312.05n 0.4 312.1n 0 316n 0 316.05n 0.5 316.1n 0.9 320n 0.9 320.05n 0.4 320.1n 0 324n 0 324.05n 0.5 324.1n 0.9 328n 0.9 328.05n 0.4 328.1n 0 332n 0 332.05n 0.5 332.1n 0.9 336n 0.9 336.05n 0.4 336.1n 0 340n 0 340.05n 0.5 340.1n 0.9 344n 0.9 344.05n 0.4 344.1n 0 348n 0 348.05n 0.5 348.1n 0.9 352n 0.9 352.05n 0.4 352.1n 0 356n 0 356.05n 0.5 356.1n 0.9 360n 0.9 360.05n 0.4 360.1n 0 364n 0 364.05n 0.5 364.1n 0.9 368n 0.9 368.05n 0.4 368.1n 0 372n 0 372.05n 0.5 372.1n 0.9 376n 0.9 376.05n 0.4 376.1n 0 380n 0 380.05n 0.5625 380.1n 0.9 384n 0.9 384.05n 0.4 384.1n 0 388n 0 388.05n 0.5 388.1n 0.9 392n 0.9 392.05n 0.4 392.1n 0 396n 0 396.05n 0.5 396.1n 0.9 400n 0.9 400.05n 0.4 400.1n 0 404n 0 404.05n 0.5 404.1n 0.9 408n 0.9 408.05n 0.4 408.1n 0 412n 0 412.05n 0.5 412.1n 0.9 416n 0.9 416.05n 0.4 416.1n 0 420n 0 420.05n 0.5 420.1n 0.9 424n 0.9 424.05n 0.4 424.1n 0 428n 0 428.05n 0.5 428.1n 0.9 432n 0.9 432.05n 0.4 432.1n 0 436n 0 436.05n 0.5 436.1n 0.9 440n 0.9 440.05n 0.4 440.1n 0 444n 0 444.05n 0.5 444.1n 0.9 448n 0.9 448.05n 0.4 448.1n 0 452n 0 452.05n 0.5 452.1n 0.9 456n 0.9 456.05n 0.4 456.1n 0 460n 0 460.05n 0.5 460.1n 0.9 464n 0.9 464.05n 0.4 464.1n 0 468n 0 468.05n 0.5 468.1n 0.9 472n 0.9 472.05n 0.4 472.1n 0 476n 0]
Vrst (rst 0) vsource type=pwl wave=[0 0.9 16n 0.9 16.05n 0.4 16.1n 0 319n 0 319.05n 0.5 319.1n 0.9 322n 0.9 322.05n 0.4 322.1n 0 476n 0]
Vstart (start 0) vsource type=pwl wave=[0 0 8n 0 8.05n 0.5 8.1n 0.9 9n 0.9 9.05n 0.4 9.1n 0 23n 0 23.05n 0.5 23.1n 0.9 23.5n 0.9 23.55n 0.4 23.6n 0 60.45n 0 60.5n 0.5 60.55n 0.9 61.4n 0.9 61.45n 0.4 61.5n 0 111n 0 111.05n 0.5 111.1n 0.9 111.5n 0.9 111.55n 0.4 111.6n 0 135n 0 135.05n 0.5 135.1n 0.9 135.5n 0.9 135.55n 0.4 135.6n 0 183n 0 183.05n 0.5 183.1n 0.9 183.5n 0.9 183.55n 0.4 183.6n 0 231n 0 231.05n 0.5 231.1n 0.9 287n 0.9 287.05n 0.4 287.1n 0 295n 0 295.05n 0.5 295.1n 0.9 295.5n 0.9 295.55n 0.4 295.6n 0 320.5n 0 320.55n 0.5 320.6n 0.9 321n 0.9 321.05n 0.4 321.1n 0 335n 0 335.05n 0.5 335.1n 0.9 335.5n 0.9 335.55n 0.4 335.6n 0 380.4n 0 380.45n 0.5 380.5n 0.9 381.4n 0.9 381.45n 0.4 381.5n 0 435.55n 0 435.6n 0.5 435.65n 0.9 437n 0.9 437.05n 0.4 437.1n 0 476n 0]

XDUT (vin clk rst start code_3 code_2 code_1 code_0 done sample_dbg dac_dbg) sar_adc_top

simulatorOptions options reltol=1e-6 vabstol=1e-8 iabstol=1e-12
tran tran stop=476n errpreset=moderate maxstep=50p strobeperiod=50p strobeoutput=strobeonly
save vin clk rst start code_3 code_2 code_1 code_0 done sample_dbg dac_dbg
