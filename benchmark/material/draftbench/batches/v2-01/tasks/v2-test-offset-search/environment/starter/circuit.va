`include "constants.vams"
`include "disciplines.vams"

module offset_search(dcmpp,ready,vinp,vinn,request,offset_est,valid,status);
inout dcmpp,ready,vinp,vinn,request,offset_est,valid,status;
electrical dcmpp,ready,vinp,vinn,request,offset_est,valid,status;
// TODO: implement the public contract.
endmodule
