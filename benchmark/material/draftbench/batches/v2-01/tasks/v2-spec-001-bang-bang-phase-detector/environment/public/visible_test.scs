simulator lang=spectre
global 0
ahdl_include "/work/dut.va"
Vdata (data 0) vsource type=pwl wave=[0 0 3n 0 3.1n .9 7n .9 7.1n 0 13n 0 13.1n .9 19n .9 19.1n 0 27n 0 27.1n .9 32n .9]
Vclk (clk 0) vsource type=pulse val0=0 val1=.9 delay=1n period=4n width=1.9n rise=50p fall=50p
Vrst (rst 0) vsource type=pwl wave=[0 .9 .3n .9 .4n 0 20n 0 20.1n .9 20.5n .9 20.6n 0 32n 0]
Ven (enable 0) vsource dc=.9
XDUT (data clk rst enable retimed up down) alexander
tran tran stop=32n maxstep=2p strobeperiod=2p
save data clk rst enable retimed up down
