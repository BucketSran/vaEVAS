simulator lang=spectre
global 0
ahdl_include "/app/circuit.va"
Vvin (vin 0) vsource type=pwl wave=[0 0.29999999999999999 3.7e-08 0.29999999999999999 3.7020000000000003e-08 1.3999999999999999 6.7000000000000004e-08 1.3999999999999999 6.7020000000000001e-08 0.40000000000000002 9.7000000000000008e-08 0.40000000000000002 9.7020000000000005e-08 1.1000000000000001 1.2700000000000001e-07 1.1000000000000001 1.2702000000000001e-07 0.69999999999999996 1.6e-07 0.69999999999999996]
Vclk (clock 0) vsource type=pwl wave=[0 0 2.9999999999999997e-08 0 3.002e-08 1.8 4.0000000000000001e-08 1.8 4.0020000000000004e-08 0 4.1000000000000003e-08 0 4.1020000000000006e-08 1.8 7.0000000000000005e-08 1.8 7.0020000000000001e-08 0 7.2000000000000009e-08 0 7.2020000000000006e-08 1.8 1.0000000000000001e-07 1.8 1.0002e-07 0 1.04e-07 0 1.0402e-07 1.8 1.3e-07 1.8 1.3002e-07 0 1.35e-07 0 1.3502e-07 1.8 1.6e-07 1.8]
XDUT (vin clock vhold) sampling_model
options options reltol=1e-6 vabstol=1e-8 iabstol=1e-14
tran tran stop=1.6e-07 maxstep=50p
save vin clock vhold
