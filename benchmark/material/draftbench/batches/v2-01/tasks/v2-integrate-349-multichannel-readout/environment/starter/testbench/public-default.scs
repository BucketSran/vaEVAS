simulator lang=spectre
global 0
ahdl_include "baseline.va"
ahdl_include "/app/circuit.va"
V0 (ch0 0) vsource dc=0.1
V1 (ch1 0) vsource dc=0.2
V2 (ch2 0) vsource dc=0.3
V3 (ch3 0) vsource dc=0.4
Vclk (clk 0) vsource type=pulse val0=0 val1=.9 delay=5n period=10n width=4n rise=100p fall=100p
Vrst (rst 0) vsource type=pwl wave=[0 .9 2n .9 2.1n 0 100n 0]
Vsample (sample 0) vsource type=pwl wave=[0 0 3n 0 3.1n .9 8n .9 8.1n 0 100n 0]
Vread (read 0) vsource type=pwl wave=[0 0 10n 0 10.1n .9 100n .9]
XDUT (ch0 ch1 ch2 ch3 clk rst sample read out sel1 sel0 valid) sample_mux_readout_top
simulatorOptions options reltol=1e-6 vabstol=1e-8 iabstol=1e-12
tran tran stop=100n maxstep=50p errpreset=conservative
save ch0 ch1 ch2 ch3 clk rst sample read out sel1 sel0 valid
