`include "constants.vams"
`include "disciplines.vams"

module hysteresis_meter(vin,cmp_out,begin_round,up,down,width,valid);
input vin,cmp_out,begin_round;
output up,down,width,valid;
electrical vin,cmp_out,begin_round,up,down,width,valid;
// TODO: implement the public contract.
endmodule
