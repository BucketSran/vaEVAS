simulator lang=spectre
ahdl_include "dut.va"
Vref (ref 0) vsource type=pwl wave=[0 0 9.99e-10 0 1e-09 0.9 1.399e-09 0.9 1.4e-09 0 2.999e-09 0 3e-09 0.9 3.399e-09 0.9 3.4e-09 0 4.999e-09 0 5e-09 0.9 5.399e-09 0.9 5.4e-09 0 6.999e-09 0 7e-09 0.9 7.399e-09 0.9 7.4e-09 0 9e-09 0]
Vfb (fb 0) vsource type=pwl wave=[0 0 1.199e-09 0 1.2e-09 0.9 1.599e-09 0.9 1.6e-09 0 3.199e-09 0 3.2e-09 0.9 3.599e-09 0.9 3.6e-09 0 5.199e-09 0 5.2e-09 0.9 5.599e-09 0.9 5.6e-09 0 7.199e-09 0 7.2e-09 0.9 7.599e-09 0.9 7.6e-09 0 9e-09 0]
Vrstb (rstb 0) vsource type=pwl wave=[0 0.9 3.049e-09 0.9 3.05e-09 0 3.999e-09 0 4e-09 0.9 5.999e-09 0.9 6e-09 0 6.499e-09 0 6.5e-09 0.9 9e-09 0.9]
Xdut (ref fb rstb up down) pfd_active_low_reset
simulatorOptions options reltol=1e-6 vabstol=1e-8 iabstol=1e-12
tran tran stop=9e-09 maxstep=5e-12 errpreset=moderate
save ref fb rstb up down
