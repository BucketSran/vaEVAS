simulator lang=spectre
global 0

ahdl_include "/app/circuit.va"
ahdl_include "/app/testbench/sar_support.va"

Vclks (clks 0) vsource type=pwl wave=[0 0 1n 0 1.05n 1 1.45n 1 1.50n 0 8n 0 8.05n 1 8.45n 1 8.50n 0 14n 0 14.05n 1 14.45n 1 14.50n 0]
Vtest (test 0) vsource dc=0
Vdtest0 (dtest0 0) vsource dc=0
Vdtest1 (dtest1 0) vsource dc=1
Vdtest2 (dtest2 0) vsource dc=0
Vdtest3 (dtest3 0) vsource dc=1
XDUT (clks dcomp dcompb test dtest0 dtest1 dtest2 dtest3 clkc dp1 dp2 dp3 dp4 dm1 dm2 dm3 dm4 dout0 dout1 dout2 dout3) sarfend_logic_4b

VIN (vin 0) vsource type=pwl wave=[0 .66 8n .66 8.1n .27 15n .27]
XSYS (clks clkc vin dp4 dp3 dp2 dp1 dcomp dcompb dac) sar_fixed_frontend

tran tran stop=15n maxstep=2p strobeperiod=2p
save clkc clks dcomp dcompb dm1 dm2 dm3 dm4 dout0 dout1 dout2 dout3 dp1 dp2 dp3 dp4 dtest0 dtest1 dtest2 dtest3 test vin dac
