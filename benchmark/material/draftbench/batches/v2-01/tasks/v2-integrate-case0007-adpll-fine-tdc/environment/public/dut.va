`include "constants.vams"
`include "disciplines.vams"
// Implement the public modules specified in instruction.md.
