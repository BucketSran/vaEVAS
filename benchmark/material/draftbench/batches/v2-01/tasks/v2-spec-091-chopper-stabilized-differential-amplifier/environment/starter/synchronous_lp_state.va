`include "constants.vams"
`include "disciplines.vams"

module synchronous_lp_state(demod_sample,baseband_ref,event_strobe,rst,enable,hold,voutp,voutn,settled,offset_residual);
input demod_sample,baseband_ref,event_strobe,rst,enable,hold;
output voutp,voutn,settled,offset_residual;
electrical demod_sample,baseband_ref,event_strobe,rst,enable,hold,voutp,voutn,settled,offset_residual;
// TODO: implement the public contract.
endmodule
