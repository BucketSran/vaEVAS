`include "constants.vams"
`include "disciplines.vams"

module acquisition_limited_sample_hold(sample,rst,vin,vout,metric);
input sample,rst,vin;
output vout,metric;
electrical sample,rst,vin,vout,metric;
// TODO: implement the public contract.
endmodule
