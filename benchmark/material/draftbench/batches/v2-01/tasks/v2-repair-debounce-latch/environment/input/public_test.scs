simulator lang=spectre
ahdl_include "dut.va"
Vsig (sig 0) vsource type=pwl wave=[0 0 1.999e-09 0 2e-09 0.9 7.999e-09 0.9 8e-09 0 1.1999e-08 0 1.2e-08 0.9 2.9999e-08 0.9 3e-08 0 3.3999e-08 0 3.4e-08 0.9 6.2e-08 0.9]
Vrst_n (rst_n 0) vsource type=pwl wave=[0 0.9 1.9999e-08 0.9 2e-08 0 2.1999e-08 0 2.2e-08 0.9 6.2e-08 0.9]
Xdut (sig rst_n out) debounce_latch
simulatorOptions options reltol=1e-6 vabstol=1e-8
tran tran stop=6.2e-08 maxstep=5e-11
save sig rst_n out
