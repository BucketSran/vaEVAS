`include "constants.vams"
`include "disciplines.vams"

module programmable_gain_amplifier(clk,rst,gain_sel,vin,out,metric);
input clk,rst,gain_sel,vin;
output out,metric;
electrical clk,rst,gain_sel,vin,out,metric;
// TODO: implement the public contract.
endmodule
