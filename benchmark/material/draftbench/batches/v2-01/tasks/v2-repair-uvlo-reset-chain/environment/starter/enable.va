`include "disciplines.vams"
module chain_enable(pgood,resetb,enable);
input pgood,resetb; output enable; electrical pgood,resetb,enable;
analog V(enable)<+ 0.9*((V(pgood)>0.45)&&(V(resetb)>0.45));
endmodule
