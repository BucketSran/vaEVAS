`include "constants.vams"
`include "disciplines.vams"

module cdac_cal(VDD,VSS,CLK,D9,D8,D7,D6,D5,D4,D3,D2,D1,D0,CAL0,CAL1,VDAC_P,VDAC_N);
input CLK,D9,D8,D7,D6,D5,D4,D3,D2,D1,D0,CAL0,CAL1;
output VDAC_P,VDAC_N;
inout VDD,VSS;
electrical VDD,VSS,CLK,D9,D8,D7,D6,D5,D4,D3,D2,D1,D0,CAL0,CAL1,VDAC_P,VDAC_N;
// TODO: implement the public contract.
endmodule
