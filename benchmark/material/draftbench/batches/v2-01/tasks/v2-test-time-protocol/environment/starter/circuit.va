`include "constants.vams"
`include "disciplines.vams"

module tdc_meter(start,stop,clk,rst,code_0,code_1,code_2,code_3,code_4,code_5,code_6,code_7,valid,overflow);
input start,stop,clk,rst;
output code_0,code_1,code_2,code_3,code_4,code_5,code_6,code_7,valid,overflow;
electrical start,stop,clk,rst,code_0,code_1,code_2,code_3,code_4,code_5,code_6,code_7,valid,overflow;
// TODO: implement the public contract.
endmodule
