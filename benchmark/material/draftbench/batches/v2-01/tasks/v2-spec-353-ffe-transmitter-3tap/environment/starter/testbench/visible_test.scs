simulator lang=spectre
global 0

ahdl_include "/app/circuit.va"

Vclk (clk 0) vsource type=pulse val0=0 val1=0.9 period=5n width=2.5n delay=1.2n rise=45p fall=45p
Vrst (rst 0) vsource type=pwl wave=[0 0.9 1.7n 0.9 1.8n 0 48n 0 48.1n 0.9 52n 0.9 52.1n 0 88n 0]
Vdata (data 0) vsource type=pwl wave=[0 0.9 7n 0.9 7.1n 0 17n 0 17.1n 0.9 27n 0.9 27.1n 0 37n 0 37.1n 0 47n 0 47.1n 0.9 62n 0.9 62.1n 0 77n 0 77.1n 0.9 88n 0.9]
Vpre0 (pre_0 0) vsource type=pwl wave=[0 0 18n 0 18.1n 0.9 44n 0.9 44.1n 0 70n 0 70.1n 0.9 88n 0.9]
Vpre1 (pre_1 0) vsource type=pwl wave=[0 0 32n 0 32.1n 0.9 60n 0.9 60.1n 0 88n 0]
Vpost0 (post_0 0) vsource type=pwl wave=[0 0.9 28n 0.9 28.1n 0 54n 0 54.1n 0.9 88n 0.9]
Vpost1 (post_1 0) vsource type=pwl wave=[0 0 42n 0 42.1n 0.9 72n 0.9 72.1n 0 88n 0]

XDUT (data clk rst pre_1 pre_0 post_1 post_0 vout main_dbg pre_dbg post_dbg) ffe_tx_3tap

simulatorOptions options reltol=1e-6 vabstol=1e-8 iabstol=1e-12
tran tran stop=88n maxstep=2p strobeperiod=2p errpreset=moderate strobeoutput=strobeonly
save data clk rst pre_1 pre_0 post_1 post_0 vout main_dbg pre_dbg post_dbg
