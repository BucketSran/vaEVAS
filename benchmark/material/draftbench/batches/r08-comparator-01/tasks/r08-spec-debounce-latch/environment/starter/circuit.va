`include "constants.vams"
`include "disciplines.vams"

module debounce_latch(sig,rst_n,out);
input sig,rst_n;
output out;
electrical sig,rst_n,out;
// TODO: implement the public contract.
endmodule
