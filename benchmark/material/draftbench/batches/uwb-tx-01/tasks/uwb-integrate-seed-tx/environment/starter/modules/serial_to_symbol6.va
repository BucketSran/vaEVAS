`include "constants.vams"
`include "disciplines.vams"

// 6-bit serial-to-parallel converter for the 8DPPM+8FSK seed (SPEC.md 4.2).
// din is sampled on rising bclk edges. The first bit after reset release is
// sym[5]. On the sixth captured bit all six outputs update together and
// sym_valid rises; sym_valid falls on the third capture of the next symbol,
// so the downstream encoder can take the word on that falling edge while the
// outputs are stable. rst is active high and asynchronous.
module uwb_serial_to_symbol6(bclk, din, rst, sym, sym_valid);
    input bclk, din, rst;
    output [5:0] sym;
    output sym_valid;
    electrical bclk, din, rst, sym_valid;
    electrical [5:0] sym;

    parameter real vdd = 1.0;
    parameter real vth = 0.5;
    parameter real tr = 2p from (0:inf);
    parameter real t_cq = 10p from (0:inf);

    integer cnt;                      // bits captured in the current symbol, 0..5
    integer s0, s1, s2, s3, s4;       // shift register, s0 holds the newest bit
    integer w0, w1, w2, w3, w4, w5;   // last complete symbol, w5 = first bit
    integer n0, n1, n2, n3, n4, n5, nvalid;   // values to show after t_cq
    integer bit_in, valid;
    real t_upd;

    analog begin
        @(initial_step) begin
            cnt = 0; s0 = 0; s1 = 0; s2 = 0; s3 = 0; s4 = 0;
            w0 = 0; w1 = 0; w2 = 0; w3 = 0; w4 = 0; w5 = 0; valid = 0;
            n0 = 0; n1 = 0; n2 = 0; n3 = 0; n4 = 0; n5 = 0; nvalid = 0; t_upd = 1.0;
        end
        @(cross(V(rst) - vth, +1)) begin
            n0 = 0; n1 = 0; n2 = 0; n3 = 0; n4 = 0; n5 = 0; nvalid = 0; t_upd = 1.0;
            cnt = 0; s0 = 0; s1 = 0; s2 = 0; s3 = 0; s4 = 0;
            w0 = 0; w1 = 0; w2 = 0; w3 = 0; w4 = 0; w5 = 0; valid = 0;
        end
        @(cross(V(bclk) - vth, +1)) begin
            if (V(rst) < vth) begin
                bit_in = V(din) > vth;
                if (cnt == 5) begin
                    // sixth bit: the five stored bits plus this one form the word
                    n5 = s4; n4 = s3; n3 = s2; n2 = s1; n1 = s0; n0 = bit_in;
                    nvalid = 1;
                    cnt = 0;
                    t_upd = $abstime + t_cq;
                end else begin
                    s4 = s3; s3 = s2; s2 = s1; s1 = s0; s0 = bit_in;
                    cnt = cnt + 1;
                    if (cnt == 3) begin
                        nvalid = 0;
                        t_upd = $abstime + t_cq;
                    end
                end
            end
        end

        // outputs follow the capture by t_cq (a timer, so all bits switch together)
        @(timer(t_upd)) begin
            w0 = n0; w1 = n1; w2 = n2; w3 = n3; w4 = n4; w5 = n5; valid = nvalid;
        end

        V(sym[0]) <+ transition(w0 * vdd, 0, tr);
        V(sym[1]) <+ transition(w1 * vdd, 0, tr);
        V(sym[2]) <+ transition(w2 * vdd, 0, tr);
        V(sym[3]) <+ transition(w3 * vdd, 0, tr);
        V(sym[4]) <+ transition(w4 * vdd, 0, tr);
        V(sym[5]) <+ transition(w5 * vdd, 0, tr);
        V(sym_valid) <+ transition(valid * vdd, 0, tr);
    end
endmodule
