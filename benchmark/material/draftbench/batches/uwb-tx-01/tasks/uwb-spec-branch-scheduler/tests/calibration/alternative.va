`include "constants.vams"
`include "disciplines.vams"

// Calibration sample: a second correct implementation with a different
// internal organization. Instead of two supply slots it keeps the state of
// every branch in packed words (3 bits of state, 2 bits of waiting grants and
// 2 bits of open windows per branch), counts the powered branches to apply
// the two-branch limit, scans for an idle HOLD to take over, and keeps the
// TAIL/idle-HOLD deadlines in a two-entry timer queue keyed by branch. The
// checker must accept it.
module ro_scheduler8(pre_a, rf_a, sel_a, pre_b, rf_b, sel_b, rst,
                     pwr, pre, rel, gate_a, gate_b, conflict, nsup, st);
    input pre_a, rf_a, pre_b, rf_b, rst;
    input [2:0] sel_a, sel_b;
    output [7:0] pwr, pre, rel, st;
    output gate_a, gate_b, conflict, nsup;
    electrical pre_a, rf_a, pre_b, rf_b, rst, gate_a, gate_b, conflict, nsup;
    electrical [2:0] sel_a, sel_b;
    electrical [7:0] pwr, pre, rel, st;

    parameter integer n_pre = 2 from [1:15];
    parameter real delta0 = 93.00595238095238p from (0:inf);
    parameter real t_tail = 150p from [0:inf);
    parameter real t_hold = 200p from [0:inf);
    parameter real t_conf = 200p from (0:inf);
    parameter real vdd = 1.0;
    parameter real vth = 0.5;
    parameter real tr = 2p from (0:inf);

    integer S, W, O;            // packed: state (3 bits), waiting grants (2 bits), open windows (2 bits)
    integer ka, kb, ga, gb;     // branch granted to each lane (-1 none), gate levels
    integer q0, q1;             // timer queue: branch whose deadline is held (-1 empty)
    real d0, d1, t_next, t_cf, idle_t;
    integer j, k, s, n, idle, conf, npow;
    genvar i;

    analog begin
        @(initial_step) begin
            S = 0; W = 0; O = 0; ka = -1; kb = -1; ga = 0; gb = 0;
            q0 = -1; q1 = -1; d0 = 1.0; d1 = 1.0; conf = 0; t_cf = 1.0;
            idle_t = t_hold - n_pre * delta0;
            if (idle_t < 0) idle_t = 0;
        end
        @(cross(V(rst) - vth, +1)) begin
            S = 0; W = 0; O = 0; ka = -1; kb = -1; ga = 0; gb = 0; q0 = -1; q1 = -1;
        end

        // ---- requests: rising pre_x, branch from sel_x
        @(cross(V(pre_a) - vth, +1)) begin
            ka = -1;
            if (V(rst) < vth) begin
                k = 4 * (V(sel_a[2]) > vth) + 2 * (V(sel_a[1]) > vth) + (V(sel_a[0]) > vth);
                n = 0; idle = -1;
                for (j = 0; j < 8; j = j + 1) begin
                    s = (S >> (3 * j)) & 7;
                    if (s != 0) n = n + 1;
                    if (s == 5 && ((W >> (2 * j)) & 3) == 0) idle = j;
                end
                s = (S >> (3 * k)) & 7;
                if (s != 0) begin
                    W = W + (1 << (2 * k)); ka = k;
                    if (s == 5 && q0 == k) q0 = -1;
                    if (s == 5 && q1 == k) q1 = -1;
                end else if (n < 2 || idle >= 0) begin
                    if (n >= 2) begin
                        S = S - 5 * (1 << (3 * idle));
                        if (q0 == idle) q0 = -1;
                        if (q1 == idle) q1 = -1;
                    end
                    S = S + (1 << (3 * k)); W = W + (1 << (2 * k)); ka = k;
                end else begin
                    conf = 1; t_cf = $abstime + t_conf;
                end
            end
        end
        @(cross(V(pre_b) - vth, +1)) begin
            kb = -1;
            if (V(rst) < vth) begin
                k = 4 * (V(sel_b[2]) > vth) + 2 * (V(sel_b[1]) > vth) + (V(sel_b[0]) > vth);
                n = 0; idle = -1;
                for (j = 0; j < 8; j = j + 1) begin
                    s = (S >> (3 * j)) & 7;
                    if (s != 0) n = n + 1;
                    if (s == 5 && ((W >> (2 * j)) & 3) == 0) idle = j;
                end
                s = (S >> (3 * k)) & 7;
                if (s != 0) begin
                    W = W + (1 << (2 * k)); kb = k;
                    if (s == 5 && q0 == k) q0 = -1;
                    if (s == 5 && q1 == k) q1 = -1;
                end else if (n < 2 || idle >= 0) begin
                    if (n >= 2) begin
                        S = S - 5 * (1 << (3 * idle));
                        if (q0 == idle) q0 = -1;
                        if (q1 == idle) q1 = -1;
                    end
                    S = S + (1 << (3 * k)); W = W + (1 << (2 * k)); kb = k;
                end else begin
                    conf = 1; t_cf = $abstime + t_conf;
                end
            end
        end

        // ---- window start: branch ACTIVE, gate up; window end: TAIL when no window is open
        @(cross(V(rf_a) - vth, +1)) begin
            if (V(rst) < vth && ka >= 0) begin
                s = (S >> (3 * ka)) & 7;
                S = S + (3 - s) * (1 << (3 * ka));
                if (((W >> (2 * ka)) & 3) > 0) W = W - (1 << (2 * ka));
                O = O + (1 << (2 * ka));
                if (q0 == ka) q0 = -1;
                if (q1 == ka) q1 = -1;
                ga = 1;
            end
        end
        @(cross(V(rf_b) - vth, +1)) begin
            if (V(rst) < vth && kb >= 0) begin
                s = (S >> (3 * kb)) & 7;
                S = S + (3 - s) * (1 << (3 * kb));
                if (((W >> (2 * kb)) & 3) > 0) W = W - (1 << (2 * kb));
                O = O + (1 << (2 * kb));
                if (q0 == kb) q0 = -1;
                if (q1 == kb) q1 = -1;
                gb = 1;
            end
        end
        @(cross(V(rf_a) - vth, -1)) begin
            if (ga) begin
                O = O - (1 << (2 * ka));
                if (((O >> (2 * ka)) & 3) == 0) begin
                    S = S + (1 << (3 * ka));                   // ACTIVE (3) -> TAIL (4)
                    if (q0 < 0) begin q0 = ka; d0 = $abstime + t_tail; end
                    else begin q1 = ka; d1 = $abstime + t_tail; end
                end
            end
            ga = 0; ka = -1;
        end
        @(cross(V(rf_b) - vth, -1)) begin
            if (gb) begin
                O = O - (1 << (2 * kb));
                if (((O >> (2 * kb)) & 3) == 0) begin
                    S = S + (1 << (3 * kb));
                    if (q0 < 0) begin q0 = kb; d0 = $abstime + t_tail; end
                    else begin q1 = kb; d1 = $abstime + t_tail; end
                end
            end
            gb = 0; kb = -1;
        end

        // ---- deadlines: end of TAIL, end of an idle HOLD
        t_next = 1.0;
        if (q0 >= 0 && d0 < t_next) t_next = d0;
        if (q1 >= 0 && d1 < t_next) t_next = d1;
        @(timer(t_next)) begin
            if (q0 >= 0 && d0 <= $abstime + 1e-15) begin
                s = (S >> (3 * q0)) & 7;
                if (s == 4) begin
                    S = S + (1 << (3 * q0));                   // TAIL -> HOLD
                    if (((W >> (2 * q0)) & 3) > 0) q0 = -1;    // waits for its window
                    else if (idle_t <= 0) begin S = S - 5 * (1 << (3 * q0)); q0 = -1; end
                    else d0 = $abstime + idle_t;
                end else begin
                    S = S - s * (1 << (3 * q0)); q0 = -1;      // idle HOLD over: OFF
                end
            end
            if (q1 >= 0 && d1 <= $abstime + 1e-15) begin
                s = (S >> (3 * q1)) & 7;
                if (s == 4) begin
                    S = S + (1 << (3 * q1));
                    if (((W >> (2 * q1)) & 3) > 0) q1 = -1;
                    else if (idle_t <= 0) begin S = S - 5 * (1 << (3 * q1)); q1 = -1; end
                    else d1 = $abstime + idle_t;
                end else begin
                    S = S - s * (1 << (3 * q1)); q1 = -1;
                end
            end
        end
        @(timer(t_cf)) conf = 0;
        t_next = 1.0;
        if (q0 >= 0 && d0 < t_next) t_next = d0;
        if (q1 >= 0 && d1 < t_next) t_next = d1;

        npow = 0;
        for (j = 0; j < 8; j = j + 1)
            if (((S >> (3 * j)) & 7) != 0) npow = npow + 1;
        for (i = 0; i < 8; i = i + 1) begin
            V(pwr[i]) <+ transition((((S >> (3 * i)) & 7) != 0) * vdd, 0, tr);
            V(pre[i]) <+ transition((((S >> (3 * i)) & 7) == 1) * vdd, 0, tr);
            V(rel[i]) <+ transition((((S >> (3 * i)) & 7) >= 3) * vdd, 0, tr);
            V(st[i]) <+ transition(0.2 * ((S >> (3 * i)) & 7), 0, tr);
        end
        V(gate_a) <+ transition(ga * vdd, 0, tr);
        V(gate_b) <+ transition(gb * vdd, 0, tr);
        V(conflict) <+ transition(conf * vdd, 0, tr);
        V(nsup) <+ transition(1.0 * npow, 0, tr);
    end
endmodule
