`include "constants.vams"
`include "disciplines.vams"
module track_hold(vin, track, rst, vout);
    input vin, track, rst;
    output vout;
    electrical vin, track, rst, vout;
    parameter real vth = 0.9;
    parameter real vinit = 0.9;
    real sample;
    analog begin
        @(initial_step) sample = vinit;
        @(cross(V(track)-vth, -1)) begin
            if (V(rst) <= vth) sample = V(vin);
        end
        @(cross(V(rst)-vth, -1)) begin
            if (V(track) <= vth) sample = vinit;
        end
        if (V(rst) > vth) V(vout) <+ vinit;
        else if (V(track) > vth) V(vout) <+ V(vin);
        else V(vout) <+ sample;
    end
endmodule
