`include "constants.vams"
`include "disciplines.vams"

module track_hold(vin, track, rst, vout);
    input vin, track, rst;
    output vout;
    electrical vin, track, rst, vout;

    // TODO: implement the specified behavior.
endmodule
