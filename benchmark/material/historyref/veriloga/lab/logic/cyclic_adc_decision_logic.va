// VerilogA for cyclicADC, digital_logic1, veriloga

`include "constants.vams"
`include "disciplines.vams"

module digital_logic1(vin1, vin2,valid, x, y, z, dm, dl);
input vin1, vin2,valid;
output x, y, z, dm, dl;
electrical vin1, vin2,valid, x, y, z, dm, dl;
parameter real vlogic_high = 5;
parameter real vlogic_low = 0;
parameter real vtrans = 1.4;
parameter real tdel = 2u from [0:inf);
parameter real trise = 1u from (0:inf);
parameter real tfall = 1u from (0:inf);

   real x_val, y_val, z_val, dm_val, dl_val;
   integer logic1, logic2,logic3;

   analog begin

      @ ( initial_step ) begin
	 if (vlogic_high < vlogic_low) begin
	    $display("Range specification error.  vlogic_high = (%E) less than vlogic_low = (%E).\n", vlogic_high, vlogic_low );
	    $finish;
	 end
	 if (vtrans > vlogic_high || vtrans < vlogic_low) begin
	    $display("Inconsistent $threshold specification w/logic family.\n");
	 end
      end

      logic1 = V(vin1) > vtrans;
      logic2 = V(vin2) > vtrans;
	logic3 = V(valid) > vtrans;

      @ (cross(V(vin1) - vtrans, 1))  logic1 = 1;
      @ (cross(V(vin1) - vtrans, -1)) logic1 = 0;

      @ (cross(V(vin2) - vtrans, 1))  logic2 = 1;
      @ (cross(V(vin2) - vtrans, -1)) logic2 = 0;
      @ (cross(V(valid) - vtrans, -1)) logic3 = 0;
     @ (cross(V(valid) - vtrans,1)) logic3 = 1;
      //
      // define the logic function.
      //

	dm_val = logic1 ? vlogic_high : vlogic_low;
	dl_val = (!logic1 && logic2)  ? vlogic_high : vlogic_low;
      	x_val =  (!logic1 && !logic2 && logic3) ? vlogic_high : vlogic_low;
	y_val =  (logic1  && logic2 && logic3)  ? vlogic_high : vlogic_low;
	z_val =  (!logic1 && logic2 && logic3)  ? vlogic_high : vlogic_low;
      	V(x) <+ transition( x_val, tdel, trise, tfall);
	V(y) <+ transition( y_val, tdel, trise, tfall);
	V(z) <+ transition( z_val, tdel, trise, tfall);
	V(dm) <+ transition( dm_val, tdel, trise, tfall);
	V(dl) <+ transition( dl_val, tdel, trise, tfall);
   end
endmodule
