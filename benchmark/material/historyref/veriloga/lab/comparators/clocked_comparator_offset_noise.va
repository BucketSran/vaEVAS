// VerilogA for ZIC_ADC, L3_comparator_V1, veriloga

`include "constants.vams"
`include "disciplines.vams"

module L2_comp(DOUT, GND, VDD, CLK, VINN, VINP);
output DOUT;
electrical DOUT;
inout GND;
electrical GND;
inout VDD;
electrical VDD;
input CLK;
electrical CLK;
input VINN;
electrical VINN;
input VINP;
electrical VINP;

parameter real td = 1n;
parameter real tr = 100p;
parameter real vos = 0;
parameter real vn = 1m;
parameter real seed_init = 0;

real vh, vl, vth;
integer d = 0;
integer seed;

analog begin

	@(initial_step) begin
		vh = V(VDD);
		vl = V(GND);
		vth = (vh + vl) / 2;
		seed = seed_init;
	end

	@(cross(V(CLK)-vth,+1)) begin
		d = V(VINP)-V(VINN) > vos+$rdist_normal(seed, 0, vn);
	end

	V(DOUT) <+ transition(d ? vh : vl, td, tr);

end

endmodule
