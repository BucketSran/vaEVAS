`include "constants.vams"
`include "disciplines.vams"

`default_transition 30p

module L2_CMP_Ideal(input electrical CMPCK, input electrical VINN, input electrical VINP, output electrical DCMPN, output electrical DCMPP);

parameter real vdd = 0.9, td_cmp = 30.0p; // comparator delay
real xoutp, xoutn;

analog begin
	@ (initial_step) begin
		xoutp = 1;
		xoutn = 1;
	end

	// fire when CMPCK goes up
	@(cross(V(CMPCK)-vdd/2,+1)) begin
		xoutp = (V(VINP) > V(VINN));
		xoutn = (V(VINP) < V(VINN));
	end

	// reset when CMPCK goes down
	@(cross(V(CMPCK)-vdd/2,-1)) begin
		xoutp = 1;
		xoutn = 1;
	end

	// set output voltage
	V(DCMPP) <+ transition(xoutp * vdd, td_cmp);
	V(DCMPN) <+ transition(xoutn * vdd, td_cmp);
end

endmodule
