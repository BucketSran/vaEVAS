// VerilogA for 10b_200M_pipesar, L2_7B_DAC, veriloga

`include "constants.vams"
`include "disciplines.vams"

`define NUM_ADC_BITS	7
`default_transition 30p

module L2_7B_DAC(input electrical [`NUM_ADC_BITS:1] DIN, input electrical RDY, output electrical AOUT);

real weight[`NUM_ADC_BITS:1] = {32,16,8,4,2,1,0.5};
real sum;

parameter real vdd = 0.9;
parameter real vth = 0.45;

real aout, cnt;
genvar i;

analog begin
	@(initial_step) begin
		sum = 1;
		for(i = `NUM_ADC_BITS; i >= 1; i = i-1) begin
			sum = sum + weight[i];
		end

		// counter, to abandon the first sample
		cnt = 0;
	end

	@(cross(V(RDY)-vth,+1)) begin
		aout = 0;
		if (cnt == 0) begin
			cnt = 1;
		end else begin
			for(i = `NUM_ADC_BITS; i >= 1; i = i-1) begin
				aout = aout + (V(DIN[i]) > vth) * weight[i];
			end
			aout = (aout/sum*2-1)*vdd;

		end
	end
	V(AOUT) <+ transition(aout,0);
end

endmodule
