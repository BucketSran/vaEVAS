// VerilogA for NEX_ADC, _tool_D2A_14bit, veriloga

`include "constants.vams"
`include "disciplines.vams"

module _tool_4bit_sar ( DIN, AOUT,SH);

parameter tr = 20p;
parameter real vth = 0.9;
parameter real gain = 0.9/16;
parameter real offset = 0;
parameter real weight[3:0] = {8,4,2,1};

input [3:0] DIN;
input SH;
output AOUT;

electrical [3:0] DIN;
electrical AOUT;
electrical SH;
real aout;

genvar i;

analog begin
        @(cross(V(SH)-vth,+1)) begin
		aout = 0;
		for(i = 0; i < 4; i=i+1) begin
			aout = aout + (V(DIN[i]) > vth ? 1 : -1) * weight[i];
		end

end
	V(AOUT) <+ transition(aout*gain+offset, 0, tr, tr);
end

endmodule
