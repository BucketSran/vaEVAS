// VerilogA for PIP_SAR_CP, cdac_6b_ideal, veriloga

`include "constants.vams"
`include "disciplines.vams"

`default_transition 30p

module L2_cdac_6b_ideal_stage1(input electrical VIN, input electrical CLKS, input electrical [5:0] DCTRL, output electrical VRES);

parameter real vdd = 1, vrefp = 1, vrefn = 0;
real vres;

analog begin

	// track (sample) when CLKS=1, hold (store) when CLKS goes down
	@ (initial_step or cross(V(CLKS)-vdd/2,-1)) begin
		vres = V(VIN);
	end

	// ajdust vres according to DCTRL
	@ (cross(V(DCTRL[5])-vdd/2, +1)) begin
		vres = vres + 0.5 * (vrefp - vrefn);
	end

	@ (cross(V(DCTRL[4])-vdd/2, +1)) begin
		vres = vres + 0.25 * (vrefp - vrefn);
	end

	@ (cross(V(DCTRL[3])-vdd/2, +1)) begin
		vres = vres + 0.125 * (vrefp - vrefn);
	end

	@ (cross(V(DCTRL[2])-vdd/2, +1)) begin
		vres = vres + 0.0625 * (vrefp - vrefn);
	end

	@ (cross(V(DCTRL[1])-vdd/2, +1)) begin
		vres = vres + 0.03125 * (vrefp - vrefn);
	end

	@ (cross(V(DCTRL[0])-vdd/2, +1)) begin
		vres = vres + 0.015625 * (vrefp - vrefn);
	end

	// output voltage assignment
	V(VRES) <+ transition(vres,0);
end

endmodule
