`include "discipline.h"
`include "constants.h"

// $Date: 1997/08/28 05:52:37 $
// $Revision: 1.1 $
//
//
// Based on the OVI Verilog-A Language Reference Manual, version 1.0 1996
//
//

//--------------------
// signum
//
// -  signum - sign of the input
//
// sigin:	(val,flow)
// sigout:	(val,flow)
//
// INSTANCE parameters
//    {none}
//
// MODEL parameters
//    {none}
//
// 'sigout' is '+1' if 'sigin' >= 0 otherwise 'sigout' is '-1'
//

module signum (sigin, sigout);
input sigin;
output sigout;
electrical sigin, sigout;

   analog
      V(sigout) <+ V(sigin) >= 0.0 ? 1 : -1;

endmodule
