`include "discipline.h"
`include "constants.h"

// $Date: 1997/08/28 05:52:34 $
// $Revision: 1.1 $
//
//
// Based on the OVI Verilog-A Language Reference Manual, version 1.0 1996
//
//

//--------------------
// power_of
//
// -  power function
//
// sigin:	(val,flow)
// sigout:	(val,flow)
//
// INSTANCE parameters
//    exponent = what 'sigin' is raised by. []
//    epsilon  = small number added to sigin to ensure that not getting
//               pow(0,0.3333..). This is because 'pow' is implemented using
//               logs. (val)
//
// MODEL parameters
//    {none}
//
// 'sigout' is 'sigin' to the power of exponent
//

module power_of (sigin, sigout);
input sigin;
output sigout;
electrical sigin, sigout;
parameter real exponent = 1;
parameter real epsilon = 1e-6;

   real sigin_val;

   analog  begin

      sigin_val = V(sigin) + epsilon;
      if ( sigin_val < 0.0 )
         V(sigout) <+ -(pow(abs(sigin_val) + epsilon,exponent));
      else
         V(sigout) <+  pow(sigin_val + epsilon,exponent);

   end
endmodule
