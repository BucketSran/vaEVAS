`include "discipline.h"
`include "constants.h"

// $Date: 1997/08/28 05:52:42 $
// $Revision: 1.1 $
//
//
// Based on the OVI Verilog-A Language Reference Manual, version 1.0 1996
//
//

//--------------------
// subtractor
//
// -  subtractor
//
// sigin_p:	input subtracted from   (val,flow)
// sigin_n:	input that's subtracted (val,flow)
// sigout:	(val,flow)
//
// INSTANCE parameters
//    {none}
//
// MODEL parameters
//    {none}
//

module subtractor(sigin_p, sigin_n, sigout);
input sigin_p, sigin_n;
output sigout;
electrical sigin_p, sigin_n, sigout;

   analog
      V(sigout) <+ V(sigin_p, sigin_n);

endmodule
