`include "discipline.h"
`include "constants.h"

// $Date: 1997/08/28 05:48:03 $
// $Revision: 1.1 $
//
//
// Based on the OVI Verilog-A Language Reference Manual, version 1.0 1996
//
//

//--------------------
// pi_controller
//
// -  proportional, integral and derivative controller
//
// sigin:	(V,I)
// sigout:	(V,I)
//
// INSTANCE parameters
//    kp = proportional gain []
//    ki = integral gain []
//
// MODEL parameters
//    {none}
//
// 'sigout' = 'kp' * sigin + 'ki' * idt ('sigin') + 'kd'* ddt ('sigin')
//
// NOTE
//    Defining larger values of 'abstol' and 'huge' for the quantities
//    associated with sigin and sigout can help overcome convergence and
//    clipping problems.
//

module pi_controller(sigin, sigout);
input sigin;
output sigout;
electrical sigin, sigout;
parameter real kp = 1 from [0:inf);
parameter real ki = 0 from [0:inf);

   analog
      V(sigout) <+ kp * V(sigin) + ki * idt (V(sigin),0);
endmodule
