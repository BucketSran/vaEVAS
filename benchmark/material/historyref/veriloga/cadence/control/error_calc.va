`include "discipline.h"
`include "constants.h"

// $Date: 1997/08/28 05:47:55 $
// $Revision: 1.1 $
//
//
// Based on the OVI Verilog-A Language Reference Manual, version 1.0 1996
//
//

//--------------------
// error_calc
//
// -  error calculation block
//
// sigset:	setpoint signal (val,flow)
// sigact:	actual value signal (val,flow)
// sigerr:	error: difference between signals (val,flow)
//
// INSTANCE parameters
//    tdel, trise, tfall = {usual}
//
// MODEL parameters
//    {none}
//
// 'sigerr' = 'sigset' - 'sigact'
//
// NOTE
//    Defining larger values of 'abstol' and 'huge' for the quantities
//    associated with sigin and sigout can help overcome convergence and
//    clipping problems.
//

module error_calc(sigset, sigact, sigerr);
input sigset, sigact;
output sigerr;
electrical sigset, sigerr;
rotational sigact;
parameter real tdel = 0;
parameter real trise = 1m from (0:inf);
parameter real tfall = 1m from (0:inf);

   analog begin

      V(sigerr) <+ transition(V(sigset) - Theta(sigact), tdel, trise, tfall);

   end

endmodule
