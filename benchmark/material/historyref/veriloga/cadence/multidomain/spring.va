`include "discipline.h"
`include "constants.h"

// $Date: 1997/08/28 05:54:14 $
// $Revision: 1.1 $
//
//
// Based on the OVI Verilog-A Language Reference Manual, version 1.0 1996
//
//

//--------------------
// spring
//
// -  kinematic spring
//
// posp,posn:	terminals [m,N]
//
// INSTANCE parameters
//    k = spring constant [N/m]
//    l = length of the spring [m]
//
// MODEL parameters
//    {none}
//

module spring (posp, posn);
inout posp, posn;
kinematic posp, posn;
parameter real k = 5000;  // spring constant in N/m
parameter real l = 0.5;   // length of spring in m

    analog
	F(posp,posn) <+ k*(Pos(posp,posn) - l);

endmodule
