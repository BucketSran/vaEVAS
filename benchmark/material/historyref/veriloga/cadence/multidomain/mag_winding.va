`include "discipline.h"
`include "constants.h"

// $Date: 1997/08/28 05:52:01 $
// $Revision: 1.1 $
// Based on the OVI Verilog-A Language Reference Manual, version 1.0 1996
//
//

`define pi	3.14159265358979323846264338327950288419716939937511
`define u0	(pi*4.0e-7) /* henrys/meter */

//--------------------
// mag_winding
//
// -  Jiles/Atherton's winding model
//
// vp:	positive voltage terminal [V,A]
// vn:	negative voltage terminal [V,A]
//
// mp:	positive MMF terminal [A,Wb]
// mn:	negative MMF terminal [A,Wb]
//
// INSTANCE parameters
//    num_turns  = number of turns []
//    rturn      = winding resistance per turn [Ohms]
//
// MODEL parameters
//    {none}
//

module mag_winding(vp,vn,mp,mn);
inout vp, vn;
inout mp, mn;
electrical vp,vn;
magnetic mp,mn;
parameter real num_turns=1;
parameter real rturn=0;

   analog begin
      MMF(mp,mn) <+ num_turns * I(vp,vn);
      V(vp,vn) <+ num_turns * (rturn * I(vp,vn) - ddt(Phi(mp,mn)));
   end
endmodule
