`include "discipline.h"
`include "constants.h"

// $Date: 1997/08/31 22:16:50 $
// $Revision: 1.1 $
// Based on the OVI Verilog-A Language Reference Manual, version 1.0 1996
//
//

`define pi	3.14159265358979323846264338327950288419716939937511
`define u0	(`pi*4.0e-7)

//--------------------
// mag_gap
//
// -  Jiles/Atherton magnetic gap model
//
// mp:	positive MMF terminal [A,Wb]
// mn:	negative MMF terminal [A,Wb]
//
// INSTANCE parameters
//    len  = effective magnetic length of gap [m]
//    area = magnetic cross-sec area of gap [m^2]
//
// MODEL parameters
//    {none}
//
// This model is analogous to a linear resistor in an electrical system.
//

module mag_gap(mp,mn);
inout mp, mn;
magnetic mp, mn;
parameter real len=0.1 from [0:inf);     // effective length
parameter real area=1 from (0:inf);      // area

   analog
      MMF(mp,mn) <+ len * Phi(mp,mn) / (`u0 * area);

endmodule
