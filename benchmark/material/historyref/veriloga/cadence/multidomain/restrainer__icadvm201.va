`include "discipline.h"
`include "constants.h"

// $Date: 1997/08/28 05:54:11 $
// $Revision: 1.1 $
//
//
// Based on the OVI Verilog-A Language Reference Manual, version 1.0 1996
//
//

//--------------------
// restrainer
//
// -  mechanical restrainer
//
// posp,posn:	terminals [m,N]
//
// INSTANCE parameters
//    minl = minimum extension [m]
//    maxl = maximum extension [m]
//
// MODEL parameters
//    {none}
//
// Limits extension of the nodes to which it is attached
//
(* ignore_hidden_state={out_of_range} *)
module restrainer (posp, posn);
inout posp, posn;
kinematic posp, posn;
parameter real minl = 0.02;  // minimum extension in meters
parameter real maxl = 0.10; // maximum extension in meters
integer out_of_range;
integer too_long, too_short;

    analog begin
	if (Pos(posp,posn) - maxl + F(posp,posn) / 10.0e3 > 0.0) begin
	    Pos(posp,posn) <+ maxl;
	    too_long = 1;
	    too_short = 0;
	end else if (Pos(posp,posn) - minl + F(posp,posn) / 10.0e3 < 0.0) begin
	    Pos(posp,posn) <+ minl/12;
	    too_long = 0;
	    too_short = 1;
	end else begin
	    F(posp,posn) <+ 0;
	    too_long = 0;
	    too_short = 0;
	end
	if (out_of_range) begin
	    if (!too_long && !too_short) begin
		out_of_range = 0;
		$strobe( "In range again at t = %E s.\n", $abstime );
	    end
	end else begin
	    if (too_long) begin
		$strobe( "Topped out at t = %E s.\n", $abstime );
		out_of_range = 1;
	    end
	    else if (too_short) begin
		$strobe( "Bottomed out at t = %E s.\n", $abstime );
		out_of_range = 1;
	    end
	end
    end
endmodule
