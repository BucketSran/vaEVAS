`include "discipline.h"
`include "constants.h"

// $Date: 1997/08/28 05:49:05 $
// $Revision: 1.1 $
//
//
// Based on the OVI Verilog-A Language Reference Manual, version 1.0 1996
//
//

//--------------------
// log_amp
//
// -  logarithmic amplifier
//
// sigin:	(val,flow)
// sigout:	(val,flow)
//
// INSTANCE parameters
//    min_sigin     = absolute value of minimum acceptable 'sigin' (val)
//    gain          = (val)
//    sigin_offset  = input offset (val)
//
// MODEL parameters
//    {none}
//
// 'sigout' is 'gain' times the natural log of the absolute value of the
// adjusted input. The adjusted input is 'sigin' minus 'sigin_offset'
// unless the absolute value of the this is less than 'min_sigin'. In
// this case 'min_sigin' is used as the adjusted input.
//

module log_amp(sigin, sigout);
input sigin;
output sigout;
electrical sigin, sigout;
parameter real min_sigin = 1e-9 from (0:inf);
parameter real gain = 1;
parameter real sigin_offset = 0;

   analog begin
      V(sigout) <+ gain * ln( max( abs( V(sigin) - sigin_offset ),
	                       min_sigin ) );
   end
endmodule
