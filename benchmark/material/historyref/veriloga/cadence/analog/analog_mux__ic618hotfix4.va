`include "discipline.h"
`include "constants.h"

// $Date: 1997/08/28 05:44:55 $
// $Revision: 1.1 $
//
//
// Based on the OVI Verilog-A Language Reference Manual, version 1.0 1996
//
//

//--------------------
// analog_mux
//
// -  analog multiplexer
//
// vin1,vin2:	[V,A]
// vsel:	selection voltage [V,A]
// vout:	[V,A]
//
// INSTANCE parameters
//    vth = 1->0 threshold voltage for the selection line [V]
//
// MODEL parameters
//    {none}
//
// When 'vsel' > 'vth', the output voltage follows 'vin1'
// When 'vsel' < 'vth', the output voltage follows 'vin2'
//
(* instrument_module *)
module analog_mux(vin1, vin2, vsel, vout);
input vin1, vin2, vsel;
output vout;
electrical vin1, vin2, vsel, vout ;
parameter real vth  = 2.5;

   integer selector;
   real vout_val;

   analog begin
      selector = (V(vsel) > vth) ? 1: 0;

      @ (cross(V(vsel) - vth, 1, 1.0, vsel.potential.abstol))
         selector = 1;

      @ (cross(V(vsel) - vth, -1, 1.0, vsel.potential.abstol))
         selector = 0;

      if (selector == 1)begin
         vout_val = V(vin1);
      end
      else if (selector == 0)begin
         vout_val = V(vin2);
      end

      V(vout) <+ vout_val;
   end
endmodule
