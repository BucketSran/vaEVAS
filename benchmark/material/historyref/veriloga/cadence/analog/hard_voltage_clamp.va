`include "discipline.h"
`include "constants.h"

// $Date: 1997/08/28 05:45:18 $
// $Revision: 1.1 $
//
//
// Based on the OVI Verilog-A Language Reference Manual, version 1.0 1996
//
//

//--------------------
// Hard voltage_clamp
//
// -  Hard voltage clamp
//
// vin:		input terminal  [V,A]
// vout:	output terminal [V,A]
// vgnd:	gnd terminal    [V,A]
//
// INSTANCE parameters
//    vclamp_upper = upper clamping voltage [A]
//    vclamp_lower = lower clamping voltage [A]
//
// MODEL parameters
//    {none}
//
// 'vout'- 'vgnd' hard clamped/limited to between 'vclamp_upper' and
// 'vclamp_lower' of 'vin' - 'vgnd'.
//

module hard_voltage_clamp(vin, vout, vgnd);
input vin;
output vout;
inout vgnd;
electrical vin, vout, vgnd;
parameter real vclamp_upper = 1;
parameter real vclamp_lower = -1;

   real vin_val, vout_val;

   analog begin

      @ ( initial_step ) begin
	 if (vclamp_upper <= vclamp_lower) begin
	    $display("Range specification error.  vclamp_upper = (%E) less than vclamp_lower = (%E).\n", vclamp_upper, vclamp_lower );
	    $finish;
	 end
      end

      vin_val = V(vin,vgnd);

      if (vin_val > vclamp_upper)      begin
      	 vout_val = vclamp_upper;
      end else if (vin_val < vclamp_lower) begin
      	 vout_val = vclamp_lower;
      end else begin
         vout_val = vin_val;
      end

      V(vout,vgnd) <+ vout_val;
   end
endmodule
