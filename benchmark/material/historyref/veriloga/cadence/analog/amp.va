`include "discipline.h"
`include "constants.h"

// $Date: 1997/08/28 05:48:44 $
// $Revision: 1.1 $
//
//
// Based on the OVI Verilog-A Language Reference Manual, version 1.0 1996
//
//

//--------------------
// amp
//
// -  amplifer
//
// sigin:	input	(val,flow)
// sigout:	output	(val,flow)
//
// INSTANCE parameters
//    gain          = gain between input and output []
//    sigin_offset  = subtracted from 'sigin' before amplification (val)
//
// MODEL parameters
//    {none}
//

module amp(sigin, sigout);
input sigin;
output sigout;
electrical sigin, sigout;
parameter real gain = 2;
parameter real sigin_offset = 0;

   analog
      V(sigout) <+ gain*(V(sigin) - sigin_offset);

endmodule
