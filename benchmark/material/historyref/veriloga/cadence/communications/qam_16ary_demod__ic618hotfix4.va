`include "discipline.h"
`include "constants.h"

// $Date: 1997/08/28 05:56:24 $
// $Revision: 1.1 $
//
//
// Based on the OVI Verilog-A Language Reference Manual, version 1.0 1996
//
//

//--------------------
// qam_16ary_demod
//
// -  QPSK (quadrature phase shift key) modulator
//
// vin:			input [V,A]
// vout_bit[0-4]:	demodulated codes [V,A]
//
// INSTANCE parameters
//    freq        = demodulation frequency [Hz]
//    vbox_width  = width of modulation code box in constellation diagram [V]
//    vlogic_high = output voltage for high [V]
//    vlogic_low  = output voltage for low  [V]
//    tdel, trise, tfall = {usual} [s]
//
// MODEL parameters
//    {none}
//
// Demodulates a 16ary encoded QAM signal by separately sampling the input
// signal at 90 Deg (q-phase) and 180 degrees (i-phase).
//
// This model does not contain a dynamic sync'ing mechanism for ensuring that
// sampling occurs at the correct time points. Syncing can be statically
// adjusted by changing 'tstart'. 'tstart' should correspond to when the
// input QAM signal is at 0 degrees.
//
// The i-phase contains the two MSB's. The q-phase contains the two LSB's.
//
// The constellation diagram representing this relationship is;
//
//                           ^
//                          / \
//                           | Q phase
//              _____________|______________
//             |      |      |      |      |
//             | 0011 | 0111 | 1011 | 1111 |
//       0     |______|______|______|______|
//             |      |      |      |      |
//       V     | 0010 | 0110 | 1010 | 1110 |
//       o  ___|______|______|______|______|___________\ I Phase
//       l     |      |      |      |      |           /
//       t     | 0001 | 0101 | 1001 | 1101 |
//       s     |______|______|______|______|
//             |      |      |      |      |
//             | 0000 | 0100 | 1000 | 1100 |
//             |______|______|______|______|
//                           |
//                           |
//                        0 Volts
//
// Each 'code' box is 'vbox_width' volts wide.
//
(* instrument_module *)
module qam_16ary_demod (vin,vout_bit0,vout_bit1,vout_bit2,vout_bit3);
input vin;
output vout_bit0,vout_bit1,vout_bit2,vout_bit3;
electrical vin,vout_bit0,vout_bit1,vout_bit2,vout_bit3;
parameter real freq=1 from (0:inf);
parameter real vbox_width = 0.1 from [0:inf);
parameter real tstart=0 from [0:inf);
parameter real vlogic_high = 5;
parameter real vlogic_low  = 0;
parameter real tdel=0 from [0:inf);
parameter real trise=1n;
parameter real tfall=1n;

   real period;

   real i_phase, q_phase;

   real vout_bit0_val;
   real vout_bit1_val;
   real vout_bit2_val;
   real vout_bit3_val;

   real tnext_i, tnext_q;

   //
   // decodes MSB of QAM_16ary phase amplitude signal
   //
   analog function real decode_msb;
      input vphase;
      input vlogic_high;
      input vlogic_low;
      real vphase;
      real vlogic_high;
      real vlogic_low;

      decode_msb = (vlogic_high - vlogic_low)*(vphase > 0) - vlogic_low;
   endfunction

   //
   // decodes LSB of QAM_16ary phase amplitude signal
   //
   analog function real decode_lsb;
      input vphase;
      input vwidth;
      input vlogic_high;
      input vlogic_low;
      real vphase;
      real vwidth;
      real vlogic_high;
      real vlogic_low;

      integer lsb;

   begin
      if (vphase > vwidth) begin
         lsb = 1;
      end else if (vphase > 0 ) begin
         lsb = 0;
      end else if (vphase > -vwidth) begin
         lsb = 1;
      end else begin
         lsb = 0;
      end

      decode_lsb =  (vlogic_high - vlogic_low)*lsb - vlogic_low;
   end
   endfunction

   analog begin

      @ ( initial_step ) begin
	 period = 1/freq;
	 tnext_i = $abstime + 0.50 * period + tstart;
	 tnext_q = $abstime + 0.25 * period + tstart;
      end

      @ ( timer( tnext_i )) begin
	 i_phase = - V(vin);
         vout_bit2_val = decode_lsb(i_phase,vbox_width,vlogic_high,vlogic_low);
         vout_bit3_val = decode_msb(i_phase,vlogic_high,vlogic_low);
	 tnext_i = tnext_i + period;
      end

      @ ( timer( tnext_q )) begin
	 q_phase = V(vin);
         vout_bit0_val = decode_lsb(q_phase,vbox_width,vlogic_high,vlogic_low);
         vout_bit1_val = decode_msb(q_phase,vlogic_high,vlogic_low);
	 tnext_q = tnext_q + period;
      end

      V(vout_bit0) <+ transition(vout_bit0_val,tdel,trise,tfall);
      V(vout_bit1) <+ transition(vout_bit1_val,tdel,trise,tfall);
      V(vout_bit2) <+ transition(vout_bit2_val,tdel,trise,tfall);
      V(vout_bit3) <+ transition(vout_bit3_val,tdel,trise,tfall);
    end
endmodule
