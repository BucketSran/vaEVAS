`include "discipline.h"
`include "constants.h"

// $Date: 2000/03/13 23:00:55 $
// $Revision: 1.2 $
//
//
// Based on the OVI Verilog-A Language Reference Manual, version 1.0 1996
//
//

//
// useful #def's
`define PI      3.14159265358979323846264338327950288419716939937511

//--------------------
// fm_modulator
//
// -  FM modulator
//
// vin:		input signal     [V,A]
// vout:	modulated signal [V,A]
//
// INSTANCE parameters
//    f_carrier = carrier frequency [Hz]
//    amp       = amplitude of the fm modulator output []
//    vin_gain  = amplification of vin_signal before it is used to modulate the
//                fm carrier signal []
//
// MODEL parameters
//    {none}
//
// 'vout' = 'amp' * sin ('phase')
// where 'phase' = idt (2 * `PI * 'f_carrier' + 'vin_gain' * 'vin')
//

module fm_modulator(vin, vout);
input vin;
output vout;
electrical vin, vout;
parameter real f_carrier = 1M;
parameter real amp = 1;
parameter real vin_gain = 1;

   real wc;			// carrier frequency in [rad/s]
   real phase_lin;		// wc*time component of phase
   real phase_nonlin;		// the idt(k*f(t)) of phase

   integer num_cycles;		// number of cycles in linear phase component

   real inst_freq;		// instanteous frequency

   analog begin

      @ ( initial_step ) begin
          wc = 2 * `PI * f_carrier;
      end

      //
      // linear portion is calculated so that it remains in the +/- 2`PI range
      // This is to ensure it's value doesn't get too large and cause rounding
      // problems for calculation of the phase.
      //
      phase_lin = wc * $abstime;
      num_cycles = phase_lin / (2*`PI);
      phase_lin = phase_lin - num_cycles * 2 * `PI;

      phase_nonlin = vin_gain * idt ( V(vin), 0);

      V(vout) <+ amp * sin (phase_lin + phase_nonlin);

      //
      // ensure that modulator output recalculated soon.
      //
      inst_freq = f_carrier + vin_gain * V(vin) / (2 * `PI);
      $bound_step (0.04 / inst_freq);
   end
endmodule
