`include "discipline.h"
`include "constants.h"

// $Date: 1997/08/28 05:56:11 $
// $Revision: 1.1 $
//
//
// Based on the OVI Verilog-A Language Reference Manual, version 1.0 1996
//
//

//--------------------
// mixer
//
// -  mixer
//
// vin1,vin2:	[V,A]
// vout:	[V,A]
//
// INSTANCE parameters
//    gain = gain of mixer []
//
// MODEL parameters
//    {none}
//
// vout = gain * vin1 * vin2

module mixer(vin1, vin2, vout);
input vin1, vin2;
output vout;
electrical vin1, vin2, vout;
parameter real gain = 1;

   analog
      V(vout) <+ gain * V(vin1)*V(vin2);

endmodule
