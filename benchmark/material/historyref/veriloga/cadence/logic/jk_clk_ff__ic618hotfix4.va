`include "discipline.h"
`include "constants.h"

// $Date: 1998/09/23 03:13:33 $
// $Revision: 1.3 $
//
//
// Based on the OVI Verilog-A Language Reference Manual, version 1.0 1996
//
//

//--------------------
// jk_clk_ff
//
// -  JK clocked flip-flop
//
// vin_j:	[V,A]
// vin_k:	[V,A]
// vclk:	[V,A]
// vout_q:	[V,A]
// vout_qbar:	[V,A]
//
// INSTANCE parameters
//    vlogic_high = output voltage for high [V]
//    vlogic_low  = output voltage for low  [V]
//    vtrans_clk  = at voltages above this, clk are considered high [V]
//    vtrans      = at voltages above this, inputs are considered high [V]
//    tdel, trise, tfall = {usual} [s]
//
// Triggered on the rising edge
//
// logic table:
//
//     J   K   Q   Q'
//   -----------------
//     0   0   0   0
//     0   0   1   1
//     0   1   0   0
//     0   1   1   0
//     1   0   0   1
//     1   0   1   1
//     1   1   0   1
//     1   1   1   0
//
(* instrument_module *)
module jk_clk_ff(vin_j, vin_k, vclk, vout_q, vout_qbar);
input vin_j, vin_k, vclk;
output vout_q, vout_qbar;
electrical vin_j, vin_k, vclk, vout_q, vout_qbar;
parameter real vlogic_high = 5;
parameter real vlogic_low = 0;
parameter real vtrans_clk = 2.5;
parameter real vtrans = 2.5;
parameter real tdel = 3u from [0:inf);
parameter real trise = 1u from (0:inf);
parameter real tfall = 1u from (0:inf);

   integer q;

   analog begin
      @ (cross( V(vclk) - vtrans_clk, +1 )) begin
         if (V(vin_j) > vtrans && V(vin_k) > vtrans) begin
            q = !q;
         end else if (V(vin_j) > vtrans && V(vin_k) < vtrans) begin
            q = 1;
         end else if (V(vin_j) < vtrans && V(vin_k) > vtrans) begin
            q = 0;
         end
      end

      V(vout_q) <+ transition( vlogic_high*q + vlogic_low*!q,
				tdel, trise, tfall);
      V(vout_qbar) <+ transition( vlogic_high*!q + vlogic_low*q,
				   tdel, trise, tfall);
    end
endmodule
