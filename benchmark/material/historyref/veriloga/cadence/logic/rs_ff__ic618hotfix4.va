`include "discipline.h"
`include "constants.h"

// $Date: 1998/09/23 03:13:33 $
// $Revision: 1.2 $
//
//
// Based on the OVI Verilog-A Language Reference Manual, version 1.0 1996
//
//

//--------------------
// rs_ff
//
// -  RS-type flip flop
//
// vin_s:		[V,A]
// vin_r:		[V,A]
// vout_q,vout_qbar:	[V,A]
//
// INSTANCE parameters
//    vlogic_high = output voltage for high [V]
//    vlogic_low  = output voltage for high [V]
//    vtrans      = voltages above this at input are considered high [V]
//    tdel, trise, tfall = {usual} [s]
//
// logic table:
//
//
//   S(t) R(t) Q(t) Q(t+e)
//   ------------------
//     0   0   0     0
//     0   0   1     1
//     0   1   0     0
//     0   1   1     0
//     1   0   0     1
//     1   0   1     1
//     1   1   0     X
//     1   1   1     X
//
//
(* instrument_module *)
module rs_ff(vin_s, vin_r, vout_q, vout_qbar);
input vin_s, vin_r;
output vout_q, vout_qbar;
electrical vin_s, vin_r, vout_q, vout_qbar;
parameter real vlogic_high = 5;
parameter real vlogic_low = 0;
parameter real vtrans = 2.5;
parameter real tdel = 3u from [0:inf);
parameter real trise = 1u from (0:inf);
parameter real tfall = 1u from (0:inf);

   integer q;
   integer input_trans1;
   integer input_trans2;

   analog begin

      input_trans1 = V(vin_s) > vtrans;
      input_trans2 = V(vin_r) > vtrans;

      //
      // trigger on both edges of the set and reset inputs.
      //
      @ (cross( V(vin_s) - vtrans, 1, 1.0, vin_s.potential.abstol))
         input_trans1 = 1;
      @ (cross( V(vin_s) - vtrans, -1, 1.0, vin_s.potential.abstol))
         input_trans1 = 0;
      @ (cross( V(vin_r) - vtrans, 1, 1.0, vin_r.potential.abstol))
         input_trans2 = 1;
      @ (cross( V(vin_r) - vtrans, -1, 1.0, vin_r.potential.abstol))
         input_trans2 = 0;

      //
      // determine the new current state and treat s=r=1 as don't care
      //
      if (input_trans1) begin
         q = 1;
      end
      else if (input_trans2) begin
         q = 0;
      end

      V(vout_q) <+ transition( vlogic_high*q + vlogic_low*!q,
				 tdel, trise, tfall );
      V(vout_qbar) <+ transition( vlogic_high*!q + vlogic_low*q,
				    tdel, trise, tfall );
   end
endmodule
