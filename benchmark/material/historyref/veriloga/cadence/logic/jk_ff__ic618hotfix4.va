`include "discipline.h"
`include "constants.h"

// $Date: 1998/09/23 03:13:33 $
// $Revision: 1.3 $
//
//
// Based on the OVI Verilog-A Language Reference Manual, version 1.0 1996
//
//

//--------------------
// jk_ff
//
// -  JK-type flip flop
//
// vin_j,vin_k:		inputs
// vout_q,vout_qbar:	outputs
//
// INSTANCE parameters
//    vlogic_high = output voltage for high [V]
//    vlogic_low  = output voltage for high [V]
//    vtrans      = voltages above this at input are considered high [V]
//    tdel, trise, tfall = {usual} [s]
//
// Triggered on the rising edge
//
// logic table:
//
//     J   K   Q   Q(t+e)
//   -----------------
//     0   0   0   0
//     0   0   1   1
//     0   1   0   0
//     0   1   1   0
//     1   0   0   1
//     1   0   1   1
//     1   1   0   1
//     1   1   1   0
//
(* instrument_module *)
module jk_ff(vin_j, vin_k, vout_q, vout_qbar);
input vin_j, vin_k;
output vout_q, vout_qbar;
electrical vin_j, vin_k, vout_q, vout_qbar;
parameter real vlogic_high = 5;
parameter real vlogic_low = 0;
parameter real vtrans = 2.5;
parameter real tdel = 3u from [0:inf);
parameter real trise = 1u from (0:inf);
parameter real tfall = 1u from (0:inf);

   integer q;
   integer J;
   integer K;
   integer trigger;

    analog begin

       @ ( initial_step ) begin
	  J = V(vin_j) > vtrans;
	  K = V(vin_k) > vtrans;
	  q = J;
       end

       trigger =0;

       //
       // trigger on both edges of the J and K inputs.
       //
       @ (cross( V(vin_j) - vtrans, 1, 1.0, vin_j.potential.abstol))begin
          J = 1;
          trigger=1;
       end
       @ (cross( V(vin_j) - vtrans, -1, 1.0, vin_j.potential.abstol))begin
          J = 0;
          trigger=1;
       end
       @ (cross( V(vin_k) - vtrans, 1, 1.0, vin_k.potential.abstol))begin
          K = 1;
          trigger=1;
       end
       @ (cross( V(vin_k) - vtrans, -1, 1.0, vin_k.potential.abstol))begin
          K = 0;
          trigger=1;
       end

       //
       // determine the new current state.
       //
       if (trigger)begin
          if (J && K) begin
             q = !q;
          end
          else if (J) begin
             q = 1;
          end
          else if (K)begin
             q = 0;
          end
       end

       V(vout_q) <+ transition( vlogic_high*q + vlogic_low*!q,
				 tdel, trise, tfall );
       V(vout_qbar) <+ transition( vlogic_high*!q + vlogic_low*q,
				    tdel, trise, tfall );
    end
endmodule
