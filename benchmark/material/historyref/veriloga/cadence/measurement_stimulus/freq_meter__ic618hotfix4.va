`include "discipline.h"
`include"constants.h"

// $Date: 1997/08/28 05:53:29 $
// $Revision: 1.1 $
//
//
// Based on the OVI Verilog-A Language Reference Manual, version 1.0 1996
//
//

`define PI  	3.14159265358979323846264338327950288419716939937511

nature Frequency
	abstol = 1m;
	access = FF;
	units = "Hz";
endnature

discipline freq_current
	potential Frequency;
	flow Current;
enddiscipline

//--------------------
// freq_meter
//
// -  Frequency meter
//
// vp,vn:	terminals [V,A]
// fout:	measured frequency [F,A]
//
// INSTANCE parameters
//    log_to_file = whether to log the results to a file; yes or no []
//    filename    = The name of the file in which the results are logged []
//
// MODEL parameters
//    {none}
//
// Measures the frequency of the voltage across the terminals by detecting
// the times at which the last two zero crossings occured. This method
// will only work accurately on single tone signals.
//
(* instrument_module *)
module freq_meter(vp,vn,fout);
electrical vp, vn;
freq_current fout;
parameter integer log_to_file = 0;

   integer out_file;

   real tlast_cross;

   real fout_val;

   analog begin

      @ ( initial_step ) begin
         if (log_to_file ) begin
             out_file = $fopen( "%C:r.dat" );
             $fstrobe(out_file,"# Generated by Spectre from module `%M'");
         end
      end

      @ ( cross (V(vp,vn),0,1.0, vp.potential.abstol) ) begin
         fout_val = 1/(2*($abstime-tlast_cross));
         tlast_cross = $abstime;
      end

      if (log_to_file) begin
         $fstrobe(out_file, "%-.10g\t%-.10g", $abstime, fout_val);
      end

      FF(fout) <+ fout_val;

      @ ( final_step ) begin
         if (log_to_file) $fclose(out_file);
      end
   end
endmodule
