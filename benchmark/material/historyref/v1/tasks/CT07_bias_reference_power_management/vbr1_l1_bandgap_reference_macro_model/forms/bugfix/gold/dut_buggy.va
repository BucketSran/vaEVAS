`include "constants.vams"
`include "disciplines.vams"

module bandgap_reference_macro_model(clk, rst, vin, out, metric);
input clk, rst, vin;
output out, metric;
electrical clk, rst, vin, out, metric;
parameter real tr = 100p;
parameter real vth = 0.45;
parameter real vstart = 0.58;
parameter real vref = 0.55;
real refv, metricv, supplyv, targetv;
analog begin
    @(initial_step) begin
        refv = 0.0;
        metricv = 0.0;
    end
    @(cross(V(clk) - vth, +1)) begin
        supplyv = V(vin);
        if (V(rst) > vth || supplyv <= 0.05) begin
            refv = 0.0;
            metricv = 0.0;
        end else begin
            targetv = 0.78 * supplyv;
            if (targetv > supplyv - 0.05) targetv = supplyv - 0.05;
            if (targetv < 0.0) targetv = 0.0;
            refv = refv + 0.35 * (targetv - refv);
            metricv = (refv > 0.48) ? 0.9 : 0.2;
        end
        if (refv > 0.9) refv = 0.9;
        if (refv < 0.0) refv = 0.0;
    end
    V(out) <+ transition(refv, 0, tr, tr);
    V(metric) <+ transition(metricv, 0, tr, tr);
end
endmodule
