`include "constants.vams"
`include "disciplines.vams"

module rf_mixer_downconverter_macro(clk, rst, vin, out, metric);
input clk, rst, vin;
output out, metric;
electrical clk, rst, vin, out, metric;
parameter real tr = 80p;
parameter real vth = 0.45;
parameter real conv_gain = 1.25;

    // TODO: implement the behavior described in visible/prompt.md.
    // This starter is intentionally incomplete; hidden tests grade behavior.
endmodule
