simulator lang=spectre
global 0

ahdl_include "window_comparator_ref.va"

V_VDD (VDD 0) vsource dc=0.9
V_VSS (VSS 0) vsource dc=0
V_vin (vin 0) vsource type=pulse val0=0 val1=0.9 period=3n delay=200p rise=50p fall=50p width=1.4n

XDUT (VDD VSS vin out) window_comparator_ref

tran tran stop=5n maxstep=100p
save VDD VSS vin
