`include "constants.vams"
`include "disciplines.vams"

// Comparator with log-linear regeneration delay: td = td_0 + tau * ln(VDD / |Vdiff_eff|)
// Physical model: output grows as Vout(t) = Vdiff * exp(t/tau), resolves when Vout = VDD.
// Calibrated: vin=10mV → td≈40ps, vin=1mV → td≈50ps  (tau=4.34ps, td_0=20.5ps)
module cmp_delay (
    input  electrical CLK,
    input  electrical VINN,
    input  electrical VINP,
    output electrical DCMPN,
    output electrical DCMPP,
    output electrical LP,
    output electrical LM,
    inout  electrical VSS,
    inout  electrical VDD
);

parameter real voffset = 0.0;
parameter real tau     = 4.34e-12;   // regeneration time constant [s]
parameter real td_0    = 20.5e-12;   // base delay offset [s]
parameter real td_min  = 20e-12;     // minimum delay floor [s]
parameter real td_max  = 200e-12;    // maximum delay ceiling [s]

    // TODO: implement the behavior described in visible/prompt.md.
    // This starter is intentionally incomplete; hidden tests grade behavior.
endmodule
