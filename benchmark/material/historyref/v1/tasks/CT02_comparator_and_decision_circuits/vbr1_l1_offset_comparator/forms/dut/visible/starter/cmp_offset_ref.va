`include "constants.vams"
`include "disciplines.vams"

module cmp_offset_ref(VDD, VSS, CLK, VINP, VINN, OUT_P);
    inout VDD, VSS;
    input CLK, VINP, VINN;
    output OUT_P;
    electrical VDD, VSS, CLK, VINP, VINN, OUT_P;

    parameter real vos = 5m;
    parameter real tt = 20p;

    // TODO: implement the behavior described in visible/prompt.md.
    // This starter is intentionally incomplete; hidden tests grade behavior.
endmodule
