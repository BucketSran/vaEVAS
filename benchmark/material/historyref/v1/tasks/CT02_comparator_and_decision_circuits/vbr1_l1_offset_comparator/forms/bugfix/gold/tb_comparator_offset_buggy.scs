simulator lang=spectre
global 0

Vvdd (VDD 0) vsource dc=0.9
Vvss (VSS 0) vsource dc=0
Vclk (CLK 0) vsource type=pulse val0=0 val1=0.9 delay=1n rise=20p fall=20p width=1n period=4n
Vinp (VINP 0) vsource type=pwl wave=[ \
    0    0.440 \
    4n   0.440 \
    4.2n 0.450 \
    8n   0.450 \
    8.2n 0.453 \
    12n  0.453 \
    12.2n 0.457 \
    16n  0.457 \
    16.2n 0.470 \
    20n  0.470 \
    20.2n 0.450 \
    24n  0.450 \
    24.2n 0.440 \
    28n  0.440 \
]
Vinn (VINN 0) vsource dc=0.450

XDUT (VDD VSS CLK VINP VINN OUT_P) cmp_offset_ref

tran tran stop=28n maxstep=20p
save CLK VINP VINN OUT_P

ahdl_include "dut_buggy.va"
