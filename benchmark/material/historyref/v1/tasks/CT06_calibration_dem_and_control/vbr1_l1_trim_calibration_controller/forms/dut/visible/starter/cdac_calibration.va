`include "constants.vams"
`include "disciplines.vams"
module cdac_calibration(clk,rst,err,trim);
    input clk,rst,err; output trim; electrical clk,rst,err,trim;
    parameter real vth=0.45; parameter real tr=500p; real acc;

    // TODO: implement the behavior described in visible/prompt.md.
    // This starter is intentionally incomplete; hidden tests grade behavior.
endmodule
