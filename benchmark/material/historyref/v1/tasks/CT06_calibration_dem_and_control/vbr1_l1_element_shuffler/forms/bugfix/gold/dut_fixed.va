`include "constants.vams"
`include "disciplines.vams"

module element_shuffler(clk, rst_n, out0, out1, out2, out3);
    input clk, rst_n;
    output out0, out1, out2, out3;
    electrical clk, rst_n, out0, out1, out2, out3;

    parameter real vth = 0.45;
    parameter real vdd = 0.9;
    parameter real tr = 300p;

    integer idx;

    analog begin
        @(initial_step) idx = 0;
        @(cross(V(rst_n) - vth, -1)) idx = 0;

        @(cross(V(clk) - vth, +1)) begin
            if (V(rst_n) > vth) begin
                idx = idx + 1;
                if (idx > 3) idx = 0;
            end
        end

        V(out0) <+ transition((idx == 2) ? vdd : 0.0, 0, tr, tr);
        V(out1) <+ transition((idx == 0) ? vdd : 0.0, 0, tr, tr);
        V(out2) <+ transition((idx == 1) ? vdd : 0.0, 0, tr, tr);
        V(out3) <+ transition((idx == 3) ? vdd : 0.0, 0, tr, tr);
    end
endmodule
