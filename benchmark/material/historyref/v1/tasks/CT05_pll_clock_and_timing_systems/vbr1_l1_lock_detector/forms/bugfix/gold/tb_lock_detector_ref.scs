simulator lang=spectre
global 0

ahdl_include "dut_fixed.va"

Vrst (rst_n 0) vsource type=pwl wave=[0 0 10n 0 11n 0.9 220n 0.9]
Vref (ref_clk 0) vsource type=pulse val0=0 val1=0.9 delay=40n period=40n width=12n rise=200p fall=200p
Vfb  (fb_clk 0) vsource type=pwl wave=[0 0 38.8n 0 39n 0.9 50n 0.9 50.2n 0 78.8n 0 79n 0.9 90n 0.9 90.2n 0 118.8n 0 119n 0.9 130n 0.9 130.2n 0 158.8n 0 159n 0.9 170n 0.9 170.2n 0 198.8n 0 199n 0.9 210n 0.9 210.2n 0]

XDUT (ref_clk fb_clk rst_n lock) lock_detector need=3 tol=2n

tran tran stop=220n maxstep=500p
save ref_clk fb_clk rst_n lock
