simulator lang=spectre
global 0

ahdl_include "pfd_updn.va"

V_VDD (VDD 0) vsource dc=0.9
V_VSS (VSS 0) vsource dc=0
V_REF (REF 0) vsource type=pulse val0=0 val1=0.9 period=3n delay=200p rise=50p fall=50p width=1.4n
V_DIV (DIV 0) vsource type=pulse val0=0 val1=0.9 period=3n delay=300p rise=50p fall=50p width=1.4n

XDUT (VDD VSS REF DIV UP DN) pfd_updn

tran tran stop=5n maxstep=100p
save VDD VSS REF DIV
