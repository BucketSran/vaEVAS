// vaBench generated partial-pass negative: metric_scale_low
// Preserves module/interface shape while intentionally violating one public contract.
`include "disciplines.vams"

module limiting_differential_amplifier(sigin_p, sigin_n, sigout);
input sigin_p, sigin_n;
output sigout;
electrical sigin_p, sigin_n, sigout;
parameter real gain = 1;
parameter real sigout_high = 10;
parameter real sigout_low = -10;
parameter real sigin_offset = 0;

real sigout_ref;
real sigout_val;

analog begin
    @(initial_step) sigout_ref = (sigout_high + sigout_low) / 2;
    sigout_val = gain * (V(sigin_p, sigin_n) - sigin_offset) + sigout_ref;
    if (sigout_val > sigout_high) begin
        sigout_val = sigout_high;
    end else if (sigout_val < sigout_low) begin
        sigout_val = sigout_low;
    end
    V(sigout) <+ (0.42 * (sigout_val));
end

endmodule
