`include "disciplines.vams"
module lt_read_sar7b_weighted(d0, d1, d2, d3, d4, d5, d6, d7, vout, gnd);
input d0, d1, d2, d3, d4, d5, d6, d7, gnd;
output vout;
electrical d0, d1, d2, d3, d4, d5, d6, d7, vout, gnd;
analog begin
    V(vout) <+ 0.0;
end
endmodule
