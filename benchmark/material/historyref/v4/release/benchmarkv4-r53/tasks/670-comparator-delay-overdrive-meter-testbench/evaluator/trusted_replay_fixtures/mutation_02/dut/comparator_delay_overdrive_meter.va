`include "disciplines.vams"
module comparator_delay_overdrive_meter(vdd, vss, clk, vinp, vinn, outp, outn, delay_ps, overdrive_mv, polarity, valid);
input vdd, vss, clk, vinp, vinn, outp, outn;
output delay_ps, overdrive_mv, polarity, valid;
electrical vdd, vss, clk, vinp, vinn, outp, outn, delay_ps, overdrive_mv, polarity, valid;
analog begin
    V(delay_ps, vss) <+ 0.0;
    V(overdrive_mv, vss) <+ 0.0;
    V(polarity, vss) <+ 0.0;
    V(valid, vss) <+ 0.0;
end
endmodule
