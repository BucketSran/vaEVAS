`include "constants.vams"
`include "disciplines.vams"

module ideal_code_dac(rst, enable, code_3, code_2, code_1, code_0, target);
    input rst, enable, code_3, code_2, code_1, code_0;
    output target;
    electrical rst, enable, code_3, code_2, code_1, code_0, target;

    parameter real vdd = 0.9;
    parameter real vss = 0.0;
    parameter real vth = 0.45;
    parameter real tr = 200p from (0:inf);

    integer code_q;
    real target_q;

    analog begin
        @(initial_step
          or cross(V(rst) - vth, +1) or cross(V(rst) - vth, -1)
          or cross(V(enable) - vth, +1) or cross(V(enable) - vth, -1)
          or cross(V(code_0) - vth, +1) or cross(V(code_0) - vth, -1)
          or cross(V(code_1) - vth, +1) or cross(V(code_1) - vth, -1)
          or cross(V(code_2) - vth, +1) or cross(V(code_2) - vth, -1)
          or cross(V(code_3) - vth, +1) or cross(V(code_3) - vth, -1)) begin
            if (V(rst) > vth || V(enable) <= vth) begin
                target_q = vss;
            end else begin
                code_q = 0;
                if (V(code_0) > vth) code_q = code_q + 1;
                if (V(code_1) > vth) code_q = code_q + 2;
                if (V(code_2) > vth) code_q = code_q + 4;
                if (V(code_3) > vth) code_q = code_q + 4;
                target_q = vss + (vdd - vss) * code_q / 15.0;
            end
        end
        V(target) <+ transition(target_q, 0.0, tr, tr);
    end
endmodule
