`include "disciplines.vams"
module safe_voltage_divider(signumer, sigdenom, sigout);
input signumer, sigdenom; output sigout; electrical signumer, sigdenom, sigout;
parameter real gain=1; parameter real min_sigdenom=1.0e-9 from (0:inf); real denominator;
analog begin denominator=V(sigdenom); if (abs(denominator)<min_sigdenom) denominator=min_sigdenom; V(sigout)<+gain*V(signumer)/denominator; end
endmodule
