simulator lang=spectre
global 0

ahdl_include "../submission/bipolar_dff_sample.va"

Vd (vin_d 0) vsource type=pwl wave=[0 -0.5 0.8n -0.5 0.85n 0.6 1.6n 0.6 1.65n -0.3 2.4n -0.3 2.45n 0.7 3.2n 0.7]
Vclk (vclk 0) vsource type=pwl wave=[0 0 0.35n 0 0.37n 0.9 0.55n 0.9 0.57n 0 1.15n 0 1.17n 0.9 1.35n 0.9 1.37n 0 1.95n 0 1.97n 0.9 2.15n 0.9 2.17n 0 2.75n 0 2.77n 0.9 2.95n 0.9 2.97n 0 3.2n 0]
XDUT (vin_d vclk vout_q vout_qbar) bipolar_dff_sample

tran tran stop=3.1n maxstep=5p
save vclk vin_d vout_q vout_qbar
