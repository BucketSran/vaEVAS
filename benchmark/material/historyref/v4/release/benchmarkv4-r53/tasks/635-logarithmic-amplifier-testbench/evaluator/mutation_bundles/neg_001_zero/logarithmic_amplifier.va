`include "disciplines.vams"

module logarithmic_amplifier (sigin, sigout);

input sigin;
output sigout;
electrical sigin, sigout;

analog begin
    V(sigout) <+ 0;
end

endmodule
