`include "disciplines.vams"
module clocked_comparator_dual_output(clk, vinn, vinp, outn, outp);
input clk, vinn, vinp;
output outn, outp;
electrical clk, vinn, vinp, outn, outp;
analog begin
    V(outp) <+ 0.0;
    V(outn) <+ 0.0;
end
endmodule
