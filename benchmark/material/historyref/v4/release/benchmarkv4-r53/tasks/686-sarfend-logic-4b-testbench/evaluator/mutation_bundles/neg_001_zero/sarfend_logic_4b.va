`include "disciplines.vams"
        module sarfend_logic_4b(clks, dcomp, dcompb, test, dtest0, dtest1, dtest2, dtest3, clkc, dp1, dp2, dp3, dp4, dm1, dm2, dm3, dm4, dout0, dout1, dout2, dout3);
        input clks, dcomp, dcompb, test, dtest0, dtest1, dtest2, dtest3;
        output clkc, dp1, dp2, dp3, dp4, dm1, dm2, dm3, dm4, dout0, dout1, dout2, dout3;
        electrical clks, dcomp, dcompb, test, dtest0, dtest1, dtest2, dtest3, clkc, dp1, dp2, dp3, dp4, dm1, dm2, dm3, dm4, dout0, dout1, dout2, dout3;

analog begin
    V(clkc) <+ 0;
    V(dp1) <+ 0;
    V(dp2) <+ 0;
    V(dp3) <+ 0;
    V(dp4) <+ 0;
    V(dm1) <+ 0;
    V(dm2) <+ 0;
    V(dm3) <+ 0;
    V(dm4) <+ 0;
    V(dout0) <+ 0;
    V(dout1) <+ 0;
    V(dout2) <+ 0;
    V(dout3) <+ 0;
end

endmodule
