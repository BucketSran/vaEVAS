`include "disciplines.vams"

module iterative_isar_dac(dcmp, rst, clk, vdac);
input dcmp, rst, clk;
output vdac;
electrical dcmp, rst, clk, vdac;

analog begin
    V(vdac) <+ 0;
end

endmodule
