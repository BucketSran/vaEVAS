`include "disciplines.vams"

module polynomial_differential_vcvs (inp, inn, outp, outn);

input inp, inn;
output outp, outn;
electrical inp, inn, outp, outn;

analog begin
    V(outp) <+ 0;
    V(outn) <+ 0;
end

endmodule
