`include "disciplines.vams"

module flash_data_align_pipeline(clk, din0, din1, din2, din3, din4, din5, din6, din7, dout0, dout1, dout2, dout3);
input clk, din0, din1, din2, din3, din4, din5, din6, din7;
output dout0, dout1, dout2, dout3;
electrical clk, din0, din1, din2, din3, din4, din5, din6, din7, dout0, dout1, dout2, dout3;

analog begin
    V(dout0) <+ 0;
    V(dout1) <+ 0;
    V(dout2) <+ 0;
    V(dout3) <+ 0;
end

endmodule
