`include "disciplines.vams"
module coarse_qtz_3bit_residue(vin, d0, d1, d2, vres);
input vin;
output d0, d1, d2, vres;
electrical vin, d0, d1, d2, vres;
analog begin
    V(d0) <+ 0.0;
    V(d1) <+ 0.0;
    V(d2) <+ 0.0;
    V(vres) <+ 0.0;
end
endmodule
