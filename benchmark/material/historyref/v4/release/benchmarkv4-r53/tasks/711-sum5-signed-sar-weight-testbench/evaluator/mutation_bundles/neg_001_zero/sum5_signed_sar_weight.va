`include "disciplines.vams"
module sum5_signed_sar_weight(d1, d2, d3, d4, d5, out);
input d1, d2, d3, d4, d5;
output out;
electrical d1, d2, d3, d4, d5, out;
analog begin
    V(out) <+ 0.0;
end
endmodule
