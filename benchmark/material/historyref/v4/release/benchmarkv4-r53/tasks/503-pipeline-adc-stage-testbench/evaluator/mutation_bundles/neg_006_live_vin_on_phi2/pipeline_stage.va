`include "constants.vams"
`include "disciplines.vams"
`default_transition 50p
module pipeline_stage(VDD, VSS, PHI1, PHI2, VIN, VREF, VRES, D1, D0);
inout VDD, VSS; input PHI1, PHI2; input VIN, VREF; output VRES; output D1, D0;
electrical VDD, VSS, PHI1, PHI2, VIN, VREF, VRES, D1, D0;
parameter real vth = 0.45; parameter real vdd = 0.9; parameter real tedge = 200p;
real vin_s, vcm, vin_rel, vref_qtr, vres_level, d1_level, d0_level, vres_drive, d1_drive, d0_drive;
analog begin
    @(initial_step) begin vin_s = 0.0; vres_level = vdd / 2.0; d1_level = 0.0; d0_level = 0.0; vres_drive = vres_level - V(VSS); d1_drive = d1_level - V(VSS); d0_drive = d0_level - V(VSS); end
    @(cross(V(PHI1) - vth, +1)) vin_s = V(VIN);
    @(cross(V(PHI2) - vth, +1)) begin
        vcm = V(VDD) / 2.0;
        vref_qtr = V(VREF) / 4.0;
        vin_rel = V(VIN) - vcm;
        if (vin_rel > vref_qtr) begin
            d1_level = V(VDD); d0_level = V(VSS);
            vres_level = vcm + 2.0 * vin_rel - V(VREF) / 2.0;
        end else if (vin_rel < -vref_qtr) begin
            d1_level = V(VSS); d0_level = V(VSS);
            vres_level = vcm + 2.0 * vin_rel + V(VREF) / 2.0;
        end else begin
            d1_level = V(VSS); d0_level = V(VDD);
            vres_level = vcm + 2.0 * vin_rel;
        end
        if (vres_level > V(VDD)) vres_level = V(VDD);
        if (vres_level < V(VSS)) vres_level = V(VSS);
        vres_drive = vres_level - V(VSS);
        d1_drive = d1_level - V(VSS);
        d0_drive = d0_level - V(VSS);
    end
    V(VRES, VSS) <+ transition(vres_drive, 0, tedge, tedge);
    V(D1, VSS) <+ transition(d1_drive, 0, tedge, tedge);
    V(D0, VSS) <+ transition(d0_drive, 0, tedge, tedge);
end
endmodule
