`include "disciplines.vams"

module flash_adc_threshold_taps(vin, clk, dout0, dout1, dout2, dout3, dout4, dout5, dout6);
input vin, clk;
output dout0, dout1, dout2, dout3, dout4, dout5, dout6;
electrical vin, clk, dout0, dout1, dout2, dout3, dout4, dout5, dout6;

analog begin
    V(dout0) <+ 0;
    V(dout1) <+ 0;
    V(dout2) <+ 0;
    V(dout3) <+ 0;
    V(dout4) <+ 0;
    V(dout5) <+ 0;
    V(dout6) <+ 0;
end

endmodule
