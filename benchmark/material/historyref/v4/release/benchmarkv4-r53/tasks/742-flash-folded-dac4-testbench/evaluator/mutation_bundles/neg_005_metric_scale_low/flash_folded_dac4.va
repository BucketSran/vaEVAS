// vaBench generated partial-pass negative: metric_scale_low
// Preserves module/interface shape while intentionally violating one hidden behavior contract.
`include "disciplines.vams"
module flash_folded_dac4(vd4, vd3, vd2, vd1, vout);
input vd4, vd3, vd2, vd1;
output vout;
electrical vd4, vd3, vd2, vd1, vout;
parameter real vth = 0.45;
parameter real vref = 1.0;
analog begin
    if (V(vd4) > vth)
        V(vout) <+ (0.42 * (vref * (8.0
            + ((V(vd3) > vth) ? 4.0 : 0.0)
            + ((V(vd2) > vth) ? 2.0 : 0.0)
            + ((V(vd1) > vth) ? 1.0 : 0.0)) / 16.0));
    else
        V(vout) <+ vref * (8.0
            - ((V(vd3) > vth) ? 4.0 : 0.0)
            - ((V(vd2) > vth) ? 2.0 : 0.0)
            - ((V(vd1) > vth) ? 1.0 : 0.0)) / 16.0;
end
endmodule
