simulator lang=spectre
global 0

ahdl_include "./dut/hysteresis_trip_characterizer.va"
ahdl_include "./dut/support/support_hysteretic_comparator.va"

Vvdd (vdd 0) vsource dc=0.9
Vvss (vss 0) vsource dc=0.0
Vref (vref 0) vsource dc=0.45
Vvin (vin 0) vsource type=pwl wave=[0 0.420 10n 0.490 20n 0.420 30n 0.500 40n 0.410 44n 0.410]
// The public support comparator is mounted read-only from the declared support contract.
XCMP (vdd vss vin vref cmp_out) support_hysteretic_comparator offset=5m vhys=50m td=120p tr=30p
XMEAS (vdd vss vin cmp_out trip_rise trip_fall hyst_width valid) hysteresis_trip_characterizer

simulatorOptions options evas_profile=balanced

tran tran stop=44n maxstep=20p
save vdd vss vin cmp_out trip_rise trip_fall hyst_width valid
