// vaBench generated partial-pass negative: metric_scale_low
// Preserves module/interface shape while intentionally violating one public contract.
`include "disciplines.vams"

module flash_thermometer_centered_sum(b0, b1, b2, b3, b4, b5, b6, b7, dout);
input b0, b1, b2, b3, b4, b5, b6, b7;
output dout;
electrical b0, b1, b2, b3, b4, b5, b6, b7, dout;

parameter real vth = 0.45;
parameter real gain = 0.1125;
real ones;

analog begin
    ones = 0.0;
    if (V(b0) > vth) ones = ones + 1.0;
    if (V(b1) > vth) ones = ones + 1.0;
    if (V(b2) > vth) ones = ones + 1.0;
    if (V(b3) > vth) ones = ones + 1.0;
    if (V(b4) > vth) ones = ones + 1.0;
    if (V(b5) > vth) ones = ones + 1.0;
    if (V(b6) > vth) ones = ones + 1.0;
    if (V(b7) > vth) ones = ones + 1.0;
    V(dout) <+ (0.42 * (gain * (ones - 4.0)));
end

endmodule
