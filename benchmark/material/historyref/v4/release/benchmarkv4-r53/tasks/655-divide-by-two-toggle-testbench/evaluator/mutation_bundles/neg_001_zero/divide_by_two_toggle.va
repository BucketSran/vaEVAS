`include "disciplines.vams"

module divide_by_two_toggle(clkin, clkout);
input clkin;
output clkout;
electrical clkin, clkout;

analog begin
    V(clkout) <+ 0;
end

endmodule
