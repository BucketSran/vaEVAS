`include "disciplines.vams"

module voltage_controlled_gain_amplifier(vin_p, vin_n, vctrl_p, vctrl_n, vout);
input vin_p, vin_n, vctrl_p, vctrl_n;
output vout;
electrical vin_p, vin_n, vctrl_p, vctrl_n, vout;

real vout_val;

analog begin
    vout_val = 1.5 * V(vctrl_p, vctrl_n) * (V(vin_p, vin_n) - 0.05) + 0.5;
    if (vout_val > 0.9) begin
        vout_val = 0.9;
    end else if (vout_val < 0.1) begin
        vout_val = 0.1;
    end
    V(vout) <+ vout_val;
end

endmodule
