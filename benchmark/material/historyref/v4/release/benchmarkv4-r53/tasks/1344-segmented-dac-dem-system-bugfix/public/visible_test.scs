simulator lang=spectre
global 0

ahdl_include "../submission/segmented_dac_dem_top.va"
ahdl_include "../submission/thermometer_decoder.va"
ahdl_include "../submission/binary_decoder.va"
ahdl_include "../submission/dwa_rotator.va"
ahdl_include "../submission/dac_driver.va"

Vclk (clk 0) vsource type=pulse val0=0 val1=0.9 period=10n width=4n delay=5n rise=100p fall=100p
Vrst (rst 0) vsource type=pwl wave=[0 0.9 2n 0.9 2.1n 0 135n 0]
Vcode_0 (code_0 0) vsource type=pwl wave=[0 0 8n 0 8.1n 0.9 18n 0.9 18.1n 0.9 28n 0.9 28.1n 0 38n 0 38.1n 0.9 48n 0.9 48.1n 0 58n 0 58.1n 0.9 68n 0.9 68.1n 0 78n 0 78.1n 0 88n 0 88.1n 0.9 98n 0.9 98.1n 0 108n 0 108.1n 0.9 118n 0.9 118.1n 0.9 135n 0.9]
Vcode_1 (code_1 0) vsource type=pwl wave=[0 0 8n 0 8.1n 0 18n 0 18.1n 0.9 28n 0.9 28.1n 0 38n 0 38.1n 0.9 48n 0.9 48.1n 0.9 58n 0.9 58.1n 0 68n 0 68.1n 0 78n 0 78.1n 0 88n 0 88.1n 0.9 98n 0.9 98.1n 0 108n 0 108.1n 0 118n 0 118.1n 0.9 135n 0.9]
Vcode_2 (code_2 0) vsource type=pwl wave=[0 0 8n 0 8.1n 0 18n 0 18.1n 0.9 28n 0.9 28.1n 0 38n 0 38.1n 0.9 48n 0.9 48.1n 0.9 58n 0.9 58.1n 0 68n 0 68.1n 0 78n 0 78.1n 0 88n 0 88.1n 0 98n 0 98.1n 0 108n 0 108.1n 0.9 118n 0.9 118.1n 0.9 135n 0.9]
Vcode_3 (code_3 0) vsource type=pwl wave=[0 0 8n 0 8.1n 0 18n 0 18.1n 0.9 28n 0.9 28.1n 0.9 38n 0.9 38.1n 0.9 48n 0.9 48.1n 0.9 58n 0.9 58.1n 0 68n 0 68.1n 0.9 78n 0.9 78.1n 0.9 88n 0.9 88.1n 0 98n 0 98.1n 0.9 108n 0.9 108.1n 0 118n 0 118.1n 0.9 135n 0.9]
Vcode_4 (code_4 0) vsource type=pwl wave=[0 0 8n 0 8.1n 0 18n 0 18.1n 0 28n 0 28.1n 0.9 38n 0.9 38.1n 0 48n 0 48.1n 0.9 58n 0.9 58.1n 0 68n 0 68.1n 0 78n 0 78.1n 0.9 88n 0.9 88.1n 0.9 98n 0.9 98.1n 0 108n 0 108.1n 0 118n 0 118.1n 0.9 135n 0.9]
Vcode_5 (code_5 0) vsource type=pwl wave=[0 0 8n 0 8.1n 0 18n 0 18.1n 0 28n 0 28.1n 0 38n 0 38.1n 0.9 48n 0.9 48.1n 0.9 58n 0.9 58.1n 0.9 68n 0.9 68.1n 0 78n 0 78.1n 0.9 88n 0.9 88.1n 0 98n 0 98.1n 0.9 108n 0.9 108.1n 0 118n 0 118.1n 0.9 135n 0.9]
XDUT (clk rst code_5 code_4 code_3 code_2 code_1 code_0 vout sel_7 sel_6 sel_5 sel_4 sel_3 sel_2 sel_1 sel_0 ptr_2 ptr_1 ptr_0) segmented_dac_dem_top

tran tran stop=135n maxstep=100p
save clk rst code_5 code_4 code_3 code_2 code_1 code_0 vout sel_7 sel_6 sel_5 sel_4 sel_3 sel_2 sel_1 sel_0 ptr_2 ptr_1 ptr_0
