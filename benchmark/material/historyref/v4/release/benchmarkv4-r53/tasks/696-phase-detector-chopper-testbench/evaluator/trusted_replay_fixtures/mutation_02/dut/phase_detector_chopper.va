`include "disciplines.vams"
        module phase_detector_chopper(vlocal_osc, vin_rf, vif);
        input vlocal_osc, vin_rf;
        output vif;
        electrical vlocal_osc, vin_rf, vif;

analog begin
    V(vif) <+ 0;
end
endmodule
