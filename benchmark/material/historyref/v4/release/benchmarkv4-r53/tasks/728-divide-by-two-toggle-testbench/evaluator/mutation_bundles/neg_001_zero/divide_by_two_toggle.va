`include "disciplines.vams"
module divide_by_two_toggle(clk, out);
input clk;
output out;
electrical clk, out;
analog begin
    V(out) <+ 0.0;
end
endmodule
