`include "disciplines.vams"

module control_word_encoder_7b(d0, d1, d2, d3, d4, d5, d6);
output d0, d1, d2, d3, d4, d5, d6;
electrical d0, d1, d2, d3, d4, d5, d6;

analog begin
    V(d0) <+ 0;
    V(d1) <+ 0;
    V(d2) <+ 0;
    V(d3) <+ 0;
    V(d4) <+ 0;
    V(d5) <+ 0;
    V(d6) <+ 0;
end

endmodule
