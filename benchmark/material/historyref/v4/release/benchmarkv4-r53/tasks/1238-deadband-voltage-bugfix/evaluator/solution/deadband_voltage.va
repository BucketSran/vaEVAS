`include "disciplines.vams"
module deadband_voltage(sigin, sigout);
input sigin;
output sigout;
electrical sigin, sigout;
parameter real sigin_dead_low = -0.25;
parameter real sigin_dead_high = 0.25;
real target;
analog begin
    if (V(sigin) < sigin_dead_low)
        target = V(sigin) - sigin_dead_low;
    else if (V(sigin) > sigin_dead_high)
        target = V(sigin) - sigin_dead_high;
    else
        target = 0.0;
    V(sigout) <+ target;
end
endmodule
