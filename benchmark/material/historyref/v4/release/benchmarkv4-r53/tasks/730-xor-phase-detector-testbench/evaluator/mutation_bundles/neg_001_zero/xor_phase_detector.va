`include "disciplines.vams"
module xor_phase_detector(ref, fb, up, down);
input ref, fb;
output up, down;
electrical ref, fb, up, down;
analog begin
    V(up) <+ 0.0;
    V(down) <+ 0.0;
end
endmodule
