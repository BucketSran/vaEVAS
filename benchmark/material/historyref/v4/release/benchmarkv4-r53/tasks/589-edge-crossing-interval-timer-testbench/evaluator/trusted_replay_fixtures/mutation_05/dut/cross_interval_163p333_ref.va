// vaBench generated partial-pass negative: reset_polarity_wrong
// Preserves module/interface shape while intentionally violating one hidden behavior contract.
`include "constants.vams"
`include "disciplines.vams"

module cross_interval_163p333_ref (
    inout  electrical VDD,
    inout  electrical VSS,
    input  electrical a,
    input  electrical b,
    output electrical delay_out,
    output electrical seen_out
);

parameter real vth = 0.45;
parameter real scale_ps = 200.0;
parameter real tedge = 20p from (0:inf);

real t_a;
real t_b;
real delay_ps;
integer seen_a;
integer seen_b;
integer done;

analog begin
    @(initial_step) begin
        t_a = 0.0;
        t_b = 0.0;
        delay_ps = 0.0;
        seen_a = 0;
        seen_b = 0;
        done = 0;
    end

    @(cross(V(a, VSS) - vth, +1)) begin
        t_a = $abstime;
        seen_a = 1;
        seen_b = 0;
        done = 0;
        delay_ps = 0.0;
    end

    @(cross(V(b, VSS) - vth, +1)) begin
        if (seen_a && !done) begin
            t_b = $abstime;
            delay_ps = (t_b - t_a) * 1.0e12;
            seen_b = 1;
            done = 1;
        end
    end

    V(delay_out, VSS) <+ (0.42 * (V(VDD, VSS) * transition(delay_ps / scale_ps, 0.0, tedge, tedge)));
    V(seen_out, VSS) <+ V(VDD, VSS) * transition((done) ? 1.0 : 0.0, 0.0, tedge, tedge);
end

endmodule
