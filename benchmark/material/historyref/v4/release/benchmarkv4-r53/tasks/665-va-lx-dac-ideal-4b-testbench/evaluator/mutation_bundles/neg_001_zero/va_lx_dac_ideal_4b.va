`include "disciplines.vams"

module va_lx_dac_ideal_4b(din1, din2, din3, din4, rdy, aout);
input din1, din2, din3, din4, rdy;
output aout;
electrical din1, din2, din3, din4, rdy, aout;

analog begin
    V(aout) <+ 0;
end

endmodule
