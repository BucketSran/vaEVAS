`include "constants.vams"
`include "disciplines.vams"

`default_transition 10p

module sample_hold(
    inout electrical VDD,
    inout electrical VSS,
    input electrical IN,
    input electrical CLK,
    output electrical OUT
);

parameter real vth = 0.45;
parameter real tedge = 100p;
real held;

analog begin
    @(initial_step) held = 0.0;
    @(cross(V(CLK, VSS) - vth, +1)) held = V(IN, VSS);
    V(OUT, VSS) <+ transition(held + 0.2, 0, tedge, tedge);
end
endmodule
