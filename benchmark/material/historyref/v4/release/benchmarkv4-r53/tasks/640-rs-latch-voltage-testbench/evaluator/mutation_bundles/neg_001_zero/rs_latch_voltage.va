`include "disciplines.vams"

module rs_latch_voltage (vin_s, vin_r, vout_q, vout_qbar);

input vin_s, vin_r;
output vout_q, vout_qbar;
electrical vin_s, vin_r, vout_q, vout_qbar;

analog begin
    V(vout_q) <+ 0;
    V(vout_qbar) <+ 0;
end

endmodule
