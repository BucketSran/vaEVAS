`include "disciplines.vams"
module sar_13bit_serial_decoder(din, clks, ready, dout, dnum);
input din, clks, ready;
output dout, dnum;
electrical din, clks, ready, dout, dnum;
analog begin
    V(dout) <+ 0.0;
    V(dnum) <+ 0.0;
end
endmodule
