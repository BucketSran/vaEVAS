`include "disciplines.vams"
module dac_restore_6bit_1p8(d1, d2, d3, d4, d5, d6, clk, vout);
input d1, d2, d3, d4, d5, d6, clk;
output vout;
electrical d1, d2, d3, d4, d5, d6, clk, vout;
analog begin
    V(vout) <+ 0.0;
end
endmodule
