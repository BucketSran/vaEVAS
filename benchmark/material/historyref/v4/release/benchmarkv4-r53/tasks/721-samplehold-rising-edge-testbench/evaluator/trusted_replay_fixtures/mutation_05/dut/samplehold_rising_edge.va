`include "disciplines.vams"
module samplehold_rising_edge(control, vin, vout);
input control, vin;
output vout;
electrical control, vin, vout;
parameter real thresh = 2.5;
parameter real tdel = 20p;
parameter real tr = 20p;
real hold;
analog begin
    @(initial_step) hold = 0.0;
    @(cross(V(control) - thresh, +1)) hold = 0.5 * V(vin);
    V(vout) <+ transition(hold, tdel, tr, tr);
end
endmodule
