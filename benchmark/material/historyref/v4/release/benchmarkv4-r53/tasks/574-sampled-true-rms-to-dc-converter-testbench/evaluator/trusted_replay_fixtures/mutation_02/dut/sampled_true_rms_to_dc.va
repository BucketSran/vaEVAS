`include "constants.vams"
`include "disciplines.vams"
module sampled_true_rms_to_dc(vinp, vinn, clk, reset, enable, rms_out, valid);
    input vinp, vinn, clk, reset, enable;
    output rms_out, valid;
    electrical vinp, vinn, clk, reset, enable, rms_out, valid;
    parameter real vth=0.45, vhigh=0.9, tr=100p from (0:inf);
    integer count, valid_state; real total, out_state, x;
    analog begin
        @(initial_step) begin count=0; valid_state=0; total=0; out_state=0; end
        @(cross(V(reset)-vth,+1)) begin count=0; valid_state=0; total=0; out_state=0; end
        @(cross(V(clk)-vth,+1)) begin
            if (V(reset)>vth) begin count=0; valid_state=0; total=0; out_state=0; end
            else begin valid_state=0; if (V(enable)>vth) begin x=V(vinp,vinn); total=total+abs(x); count=count+1;
                if (count==4) begin out_state=total/4.0; count=0; total=0; valid_state=1; end end end
        end
        V(rms_out)<+transition(out_state,0,tr,tr); V(valid)<+transition(valid_state?vhigh:0,0,tr,tr);
    end
endmodule
