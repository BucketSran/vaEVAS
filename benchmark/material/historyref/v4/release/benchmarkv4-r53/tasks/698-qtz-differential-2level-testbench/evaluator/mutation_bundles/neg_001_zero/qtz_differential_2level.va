`include "disciplines.vams"
        module qtz_differential_2level(vinp, vinn, vrefp, vrefn, clk, dout);
        input vinp, vinn, vrefp, vrefn, clk;
        output dout;
        electrical vinp, vinn, vrefp, vrefn, clk, dout;

analog begin
    V(dout) <+ 0;
end
endmodule
