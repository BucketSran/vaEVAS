// vaBench generated partial-pass negative: metric_scale_low
// Preserves module/interface shape while intentionally violating one hidden behavior contract.
`include "disciplines.vams"

module two_bit_counter_marker (CLKIN, MC);

input CLKIN;
output MC;
electrical CLKIN, MC;

integer count = 0;
integer mc = 0;

analog begin
    @(initial_step) begin
        count = 0;
        mc = 0;
    end

    @(cross(V(CLKIN) - 0.5, +1)) begin
        if (count == 3) begin
            count = 0;
            mc = 1;
        end else begin
            count = count + 1;
            mc = 0;
        end
    end

    V(MC) <+ (0.42 * (transition(mc, 10p, 10p, 10p)));
end

endmodule
