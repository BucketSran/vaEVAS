`include "disciplines.vams"
module clocked_adc3bit(vd2, vd1, vd0, vin, vclk);
output vd2, vd1, vd0;
input vin, vclk;
electrical vd2, vd1, vd0, vin, vclk;
analog begin
    V(vd0) <+ 0.0;
    V(vd1) <+ 0.0;
    V(vd2) <+ 0.0;
end
endmodule
