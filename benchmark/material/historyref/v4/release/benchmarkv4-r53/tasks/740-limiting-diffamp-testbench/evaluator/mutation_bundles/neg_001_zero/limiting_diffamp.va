`include "disciplines.vams"
module limiting_diffamp(sigin_p, sigin_n, sigout);
input sigin_p, sigin_n;
output sigout;
electrical sigin_p, sigin_n, sigout;
analog begin
    V(sigout) <+ 0.0;
end
endmodule
