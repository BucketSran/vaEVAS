`include "disciplines.vams"

module pipe_2lane_edge_align(din1, din2, clk_align, dout);
input din1, din2, clk_align;
output dout;
electrical din1, din2, clk_align, dout;

analog begin
    V(dout) <+ 0;
end

endmodule
