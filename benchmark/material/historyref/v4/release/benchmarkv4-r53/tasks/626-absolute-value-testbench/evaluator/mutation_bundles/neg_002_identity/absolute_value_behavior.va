`include "disciplines.vams"
module absolute_value_behavior(sigin, sigout);
input sigin; output sigout; electrical sigin, sigout;
analog begin V(sigout) <+ V(sigin); end
endmodule
