`include "disciplines.vams"

module hard_voltage_clamp_behavior (vin, vout, vgnd);

input vin, vgnd;
output vout;
electrical vin, vout, vgnd;

analog begin
    V(vout) <+ 0;
end

endmodule
