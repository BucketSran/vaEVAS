simulator lang=spectre
global 0

ahdl_include "../submission/pll_timing_monitor_top.va"
ahdl_include "../submission/phase_detector.va"
ahdl_include "../submission/divider.va"
ahdl_include "../submission/lock_detector.va"
ahdl_include "../submission/reacquire_timer.va"

Vrst (rst 0) vsource type=pwl wave=[0 0.9 3n 0.9 3.1n 0 240n 0]
Venable (enable 0) vsource type=pwl wave=[0 0 4n 0 4.1n 0.9 206.5n 0.9 206.6n 0 218n 0 218.1n 0.9 240n 0.9]
Vref_clk (ref_clk 0) vsource type=pwl wave=[0 0 4.95n 0 5n 0.9 7.5n 0.9 7.55n 0 14.95n 0 15n 0.9 17.5n 0.9 17.55n 0 24.95n 0 25n 0.9 27.5n 0.9 27.55n 0 34.95n 0 35n 0.9 37.5n 0.9 37.55n 0 44.95n 0 45n 0.9 47.5n 0.9 47.55n 0 54.95n 0 55n 0.9 57.5n 0.9 57.55n 0 64.95n 0 65n 0.9 67.5n 0.9 67.55n 0 74.95n 0 75n 0.9 77.5n 0.9 77.55n 0 84.95n 0 85n 0.9 87.5n 0.9 87.55n 0 94.95n 0 95n 0.9 97.5n 0.9 97.55n 0 104.95n 0 105n 0.9 107.5n 0.9 107.55n 0 114.95n 0 115n 0.9 117.5n 0.9 117.55n 0 124.95n 0 125n 0.9 127.5n 0.9 127.55n 0 134.95n 0 135n 0.9 137.5n 0.9 137.55n 0 144.95n 0 145n 0.9 147.5n 0.9 147.55n 0 154.95n 0 155n 0.9 157.5n 0.9 157.55n 0 164.95n 0 165n 0.9 167.5n 0.9 167.55n 0 174.95n 0 175n 0.9 177.5n 0.9 177.55n 0 184.95n 0 185n 0.9 187.5n 0.9 187.55n 0 194.95n 0 195n 0.9 197.5n 0.9 197.55n 0 204.95n 0 205n 0.9 207.5n 0.9 207.55n 0 214.95n 0 215n 0.9 217.5n 0.9 217.55n 0 224.95n 0 225n 0.9 227.5n 0.9 227.55n 0 240n 0]
Vfb_clk (fb_clk 0) vsource type=pwl wave=[0 0 5.6n 0 5.65n 0.9 8.15n 0.9 8.2n 0 14.3n 0 14.35n 0.9 16.85n 0.9 16.9n 0 25.6n 0 25.65n 0.9 28.15n 0.9 28.2n 0 34.3n 0 34.35n 0.9 36.85n 0.9 36.9n 0 45.6n 0 45.65n 0.9 48.15n 0.9 48.2n 0 54.3n 0 54.35n 0.9 56.85n 0.9 56.9n 0 65.6n 0 65.65n 0.9 68.15n 0.9 68.2n 0 74.3n 0 74.35n 0.9 76.85n 0.9 76.9n 0 85.6n 0 85.65n 0.9 88.15n 0.9 88.2n 0 94.3n 0 94.35n 0.9 96.85n 0.9 96.9n 0 105.6n 0 105.65n 0.9 108.15n 0.9 108.2n 0 115.6n 0 115.65n 0.9 118.15n 0.9 118.2n 0 125.6n 0 125.65n 0.9 128.15n 0.9 128.2n 0 135.6n 0 135.65n 0.9 138.15n 0.9 138.2n 0 145.6n 0 145.65n 0.9 148.15n 0.9 148.2n 0 155.6n 0 155.65n 0.9 158.15n 0.9 158.2n 0 165.6n 0 165.65n 0.9 168.15n 0.9 168.2n 0 175.6n 0 175.65n 0.9 178.15n 0.9 178.2n 0 185.6n 0 185.65n 0.9 188.15n 0.9 188.2n 0 195.6n 0 195.65n 0.9 198.15n 0.9 198.2n 0 205.6n 0 205.65n 0.9 208.15n 0.9 208.2n 0 215.6n 0 215.65n 0.9 218.15n 0.9 218.2n 0 225.6n 0 225.65n 0.9 228.15n 0.9 228.2n 0 240n 0]

XDUT (ref_clk fb_clk rst enable up down lock reacquire div2_clk phase_3 phase_2 phase_1 phase_0) pll_timing_monitor_top

tran tran stop=240n maxstep=100p
save ref_clk fb_clk rst enable up down lock reacquire div2_clk phase_3 phase_2 phase_1 phase_0
