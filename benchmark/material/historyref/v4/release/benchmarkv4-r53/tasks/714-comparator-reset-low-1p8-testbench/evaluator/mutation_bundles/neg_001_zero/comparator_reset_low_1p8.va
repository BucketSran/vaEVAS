`include "disciplines.vams"
module comparator_reset_low_1p8(cmpck, vinn, vinp, dcmpn, dcmpp);
input cmpck, vinn, vinp;
output dcmpn, dcmpp;
electrical cmpck, vinn, vinp, dcmpn, dcmpp;
analog begin
    V(dcmpp) <+ 0.0;
    V(dcmpn) <+ 0.0;
end
endmodule
