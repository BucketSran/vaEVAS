`include "disciplines.vams"
module mux4_priority(sel0, sel1, in0, in1, in2, in3, out);
input sel0, sel1, in0, in1, in2, in3;
output out;
electrical sel0, sel1, in0, in1, in2, in3, out;
analog begin
    V(out) <+ 0.0;
end
endmodule
