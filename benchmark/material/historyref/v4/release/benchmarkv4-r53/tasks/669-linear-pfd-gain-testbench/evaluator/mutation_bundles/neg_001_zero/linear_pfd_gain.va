`include "disciplines.vams"

module linear_pfd_gain(in1, in2, out);
input in1, in2;
output out;
electrical in1, in2, out;

analog begin
    V(out) <+ 0;
end

endmodule
