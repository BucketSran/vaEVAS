// vaBench generated partial-pass negative: metric_scale_low
// Preserves module/interface shape while intentionally violating one behavioral contract.
`include "disciplines.vams"

module attenuator_gain (vin, vout);

input vin;
output vout;
electrical vin, vout;

parameter real attenuation = 0;
real gain;

analog begin
    @(initial_step) gain = 1 / pow(10, attenuation / 20);
    V(vout) <+ (0.42 * (gain * V(vin)));
end

endmodule
