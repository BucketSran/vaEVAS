`include "disciplines.vams"

module cyclic_decoder_12bit(d0, d1, d2, d3, d4, d5, d6, d7, d8, d9, d10, d11, clks, dout);
input d0, d1, d2, d3, d4, d5, d6, d7, d8, d9, d10, d11, clks;
output dout;
electrical d0, d1, d2, d3, d4, d5, d6, d7, d8, d9, d10, d11, clks, dout;

analog begin
    V(dout) <+ 0;
end

endmodule
