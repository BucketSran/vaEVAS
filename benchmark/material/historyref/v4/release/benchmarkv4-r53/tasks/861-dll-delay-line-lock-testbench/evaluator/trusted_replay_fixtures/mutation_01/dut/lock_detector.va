`include "constants.vams"
`include "disciplines.vams"

module lock_detector(decision_clk, up, down, edge_error, rst, enable, delay_4, delay_3, delay_2, delay_1, delay_0, lock);
    input decision_clk, up, down, edge_error, rst, enable;
    output delay_4, delay_3, delay_2, delay_1, delay_0, lock;
    electrical decision_clk, up, down, edge_error, rst, enable, delay_4, delay_3, delay_2, delay_1, delay_0, lock;

    parameter real vdd = 0.9;
    parameter real vss = 0.0;
    parameter real vth = 0.45;
    parameter integer delay_center = 16;
    parameter integer lock_window = 1;
    parameter real tr = 100p;

    integer code;
    integer good_count;
    integer locked_state;
    real abs_err;

    analog begin
        @(initial_step) begin
            code = delay_center;
            good_count = 0;
            locked_state = 0;
        end

        @(cross(V(rst) - vth, +1) or cross(V(enable) - vth, -1)) begin
            code = delay_center;
            good_count = 0;
            locked_state = 0;
        end

        @(cross(V(decision_clk) - vth, +1) or cross(V(decision_clk) - vth, -1)) begin
            if (V(rst) <= vth && V(enable) > vth) begin
                if (V(up) > vth && code < 31) code = code + 1;
                if (V(down) > vth && code > 0) code = code - 1;

                abs_err = V(edge_error);
                if (abs_err < 0.0) abs_err = -abs_err;
                if (abs_err <= lock_window) begin
                    good_count = good_count + 1;
                    if (good_count >= 4) locked_state = 1;
                end else begin
                    good_count = 0;
                    locked_state = 0;
                end
            end
        end

        V(delay_4) <+ transition(((code / 16) % 2) ? vdd : vss, 0, tr, tr);
        V(delay_3) <+ transition(((code / 8) % 2) ? vdd : vss, 0, tr, tr);
        V(delay_2) <+ transition(((code / 4) % 2) ? vdd : vss, 0, tr, tr);
        V(delay_1) <+ transition(((code / 2) % 2) ? vdd : vss, 0, tr, tr);
        V(delay_0) <+ transition((code % 2) ? vdd : vss, 0, tr, tr);
        V(lock) <+ transition(locked_state ? vdd : vss, 0, tr, tr);
    end
endmodule
