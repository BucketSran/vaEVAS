`include "constants.vams"
`include "disciplines.vams"

module bipolar_dac_4b_continuous(vd3, vd2, vd1, vd0, vout);
    input vd3, vd2, vd1, vd0;
    output vout;
    electrical vd3, vd2, vd1, vd0, vout;
    parameter real vref = 0.9;
    parameter real trise = 20p;
    parameter real tfall = 20p;
    parameter real tdel = 0;
    parameter real vtrans = 0.45;

    analog begin
        V(vout) <+ transition(0.0, tdel, trise, tfall);
    end
endmodule
