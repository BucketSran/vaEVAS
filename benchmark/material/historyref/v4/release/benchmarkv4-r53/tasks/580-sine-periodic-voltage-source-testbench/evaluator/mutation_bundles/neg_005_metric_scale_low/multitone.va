// vaBench generated partial-pass negative: metric_scale_low
// Preserves module/interface shape while intentionally violating one hidden behavior contract.
`include "constants.vams"
`include "disciplines.vams"

module multitone(VSS, OUT);
    input VSS;
    output OUT;
    electrical VSS, OUT;

    parameter real f1 = 1.0e6;
    parameter real f2 = 2.0e6;
    parameter real f3 = 3.0e6;
    parameter real a1 = 0.2;
    parameter real a2 = 0.1;
    parameter real a3 = 0.05;

    analog begin
        $bound_step(0.02 / f3);
        V(OUT, VSS) <+ (0.42 * (a1 * sin(2.0 * `M_PI * f1 * $abstime)
                     + a2 * sin(2.0 * `M_PI * f2 * $abstime)
                     + a3 * sin(2.0 * `M_PI * f3 * $abstime)));
    end
endmodule
