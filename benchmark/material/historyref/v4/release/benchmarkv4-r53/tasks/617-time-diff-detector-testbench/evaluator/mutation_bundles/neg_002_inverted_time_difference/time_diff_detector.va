`include "disciplines.vams"
module time_diff_detector (clk, vinp, vinn, vout);
input clk, vinp, vinn; output vout; electrical clk, vinp, vinn, vout;
parameter real vdd=0.9; parameter real vth_clk=0.45; parameter real vth_in=0.45; parameter real td=0; parameter real tr=1p; parameter real scale=1e9;
real t_vinp_rise, t_vinn_rise, vout_val; integer detect_enable_p, detect_enable_n, detected_p, detected_n;
analog begin
    @(initial_step) begin detect_enable_p=0; detect_enable_n=0; detected_p=0; detected_n=0; t_vinp_rise=0; t_vinn_rise=0; vout_val=0; end
    @(cross(V(clk)-vth_clk,+1)) begin
        vout_val = (t_vinn_rise - t_vinp_rise) * scale;
        if (vout_val > vdd) vout_val = vdd; if (vout_val < -vdd) vout_val = -vdd;
        detect_enable_p=1; detect_enable_n=1; detected_p=0; detected_n=0; t_vinp_rise=0; t_vinn_rise=0;
    end
    @(cross(V(vinp)-vth_in,+1)) if (detect_enable_p && !detected_p) begin t_vinp_rise=$abstime; detected_p=1; end
    @(cross(V(vinn)-vth_in,+1)) if (detect_enable_n && !detected_n) begin t_vinn_rise=$abstime; detected_n=1; end
    V(vout) <+ transition(vout_val, td, tr);
end
endmodule
