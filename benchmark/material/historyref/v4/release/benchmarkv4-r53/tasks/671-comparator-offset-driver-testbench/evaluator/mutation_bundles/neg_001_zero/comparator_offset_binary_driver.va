`include "disciplines.vams"

module comparator_offset_binary_driver(clk, dcmpp, vinp, vinn);
input clk, dcmpp;
output vinp, vinn;
electrical clk, dcmpp, vinp, vinn;

analog begin
    V(vinp) <+ 0;
    V(vinn) <+ 0;
end

endmodule
