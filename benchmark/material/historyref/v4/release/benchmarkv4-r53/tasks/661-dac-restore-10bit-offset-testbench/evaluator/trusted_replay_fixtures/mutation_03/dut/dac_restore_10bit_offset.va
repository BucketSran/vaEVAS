`include "disciplines.vams"

module dac_restore_10bit_offset(D1, D2, D3, D4, D5, D6, D7, D8, D9, D10, D0, clk, vout);
input D1, D2, D3, D4, D5, D6, D7, D8, D9, D10, D0, clk;
output vout;
electrical D1, D2, D3, D4, D5, D6, D7, D8, D9, D10, D0, clk, vout;

analog begin
    V(vout) <+ 0;
end

endmodule
