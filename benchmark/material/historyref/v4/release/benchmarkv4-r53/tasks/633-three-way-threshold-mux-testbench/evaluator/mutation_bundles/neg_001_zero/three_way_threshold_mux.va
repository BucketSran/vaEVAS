`include "disciplines.vams"

module three_way_threshold_mux (sigin1, sigin2, sigin3, cntrlp, cntrlm, sigout);

input sigin1, sigin2, sigin3, cntrlp, cntrlm;
output sigout;
electrical sigin1, sigin2, sigin3, cntrlp, cntrlm, sigout;

analog begin
    V(sigout) <+ 0;
end

endmodule
