`include "disciplines.vams"

module sar_weighted_sum (D10, D9, D8, D7, D6, D5, D4, D3, D2, D1, D0, VOUT);

input D10, D9, D8, D7, D6, D5, D4, D3, D2, D1, D0;
output VOUT;
electrical D10, D9, D8, D7, D6, D5, D4, D3, D2, D1, D0, VOUT;

analog begin
    V(VOUT) <+ 0;
end

endmodule
