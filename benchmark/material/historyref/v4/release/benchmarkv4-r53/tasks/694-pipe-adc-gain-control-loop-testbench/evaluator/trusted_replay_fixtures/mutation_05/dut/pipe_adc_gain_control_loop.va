`include "disciplines.vams"
        module pipe_adc_gain_control_loop(din20, din21, din22, din23, din24, din25, din26, clks, dout10, dout11, dout12, dout13, gainctrl0, gainctrl1, gainctrl2, gainctrl3, gainctrl4, gainctrl5, gainctrl6, ddiff, dop, dom, gctrlcode);
        input din20, din21, din22, din23, din24, din25, din26, clks;
        output dout10, dout11, dout12, dout13, gainctrl0, gainctrl1, gainctrl2, gainctrl3, gainctrl4, gainctrl5, gainctrl6, ddiff, dop, dom, gctrlcode;
        electrical din20, din21, din22, din23, din24, din25, din26, clks, dout10, dout11, dout12, dout13, gainctrl0, gainctrl1, gainctrl2, gainctrl3, gainctrl4, gainctrl5, gainctrl6, ddiff, dop, dom, gctrlcode;

analog begin
    V(dout10) <+ 0;
    V(dout11) <+ 0;
    V(dout12) <+ 0;
    V(dout13) <+ 0;
    V(gainctrl0) <+ 0;
    V(gainctrl1) <+ 0;
    V(gainctrl2) <+ 0;
    V(gainctrl3) <+ 0;
    V(gainctrl4) <+ 0;
    V(gainctrl5) <+ 0;
    V(gainctrl6) <+ 0;
    V(ddiff) <+ 0;
    V(dop) <+ 0;
    V(dom) <+ 0;
    V(gctrlcode) <+ 0;
end
endmodule
