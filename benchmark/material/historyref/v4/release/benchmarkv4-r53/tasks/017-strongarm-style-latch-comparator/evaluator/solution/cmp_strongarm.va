`include "constants.vams"
`include "disciplines.vams"

module cmp_strongarm (
    input  electrical CLK,
    input  electrical VINN,
    input  electrical VINP,
    output electrical DCMPN,
    output electrical DCMPP,
    output electrical LP,
    output electrical LM,
    inout  electrical VSS,
    inout  electrical VDD
);

parameter real td_cmp = 0.0;
parameter real voffset = 0.0;

real vdd;
integer xoutp, xoutn;
real tedge = 20p;

real v_diff_ideal;
real v_diff_offset;

analog begin
    vdd = V(VDD);

    v_diff_ideal = V(VINP) - V(VINN);
    v_diff_offset = v_diff_ideal - voffset;

    @(initial_step) begin
        xoutp = 0;
        xoutn = 0;
    end

    @(cross(V(CLK) - vdd*0.5, +1)) begin
        xoutp = (v_diff_offset > 0);
        xoutn = (v_diff_offset < 0);
    end

    @(cross(V(CLK) - vdd*0.5, -1)) begin
        xoutp = 0;
        xoutn = 0;
    end

    V(DCMPP) <+ vdd * transition(xoutp, td_cmp, tedge, tedge);
    V(DCMPN) <+ vdd * transition(xoutn, td_cmp, tedge, tedge);
    V(LP) <+ vdd * transition(xoutp, td_cmp, tedge, tedge);
    V(LM) <+ vdd * transition(xoutn, td_cmp, tedge, tedge);

end

endmodule
