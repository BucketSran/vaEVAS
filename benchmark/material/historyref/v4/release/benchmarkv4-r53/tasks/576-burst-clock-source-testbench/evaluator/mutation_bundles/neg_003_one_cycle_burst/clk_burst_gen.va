`include "constants.vams"
`include "disciplines.vams"

module clk_burst_gen(CLK, RST_N, CLK_OUT);
    input CLK, RST_N;
    output CLK_OUT;
    electrical CLK, RST_N, CLK_OUT;
    parameter integer div = 8;
    parameter real vdd = 0.9;
    parameter real vth = 0.45;
    integer count;
    integer gate;
    integer clk_hi;
    analog begin
        @(initial_step) begin
            count = 0;
            gate = 0;
            clk_hi = 0;
        end
        @(cross(V(CLK) - vth, +1)) begin
            clk_hi = 1;
            if (V(RST_N) < vth) begin
                count = 0;
                gate = 0;
            end else begin
                gate = (count == 0);
                count = count + 1;
                if (count >= div) count = 0;
            end
        end
        @(cross(V(CLK) - vth, -1)) clk_hi = 0;
        V(CLK_OUT) <+ transition((gate && clk_hi) ? vdd : 0.0);
    end
endmodule
