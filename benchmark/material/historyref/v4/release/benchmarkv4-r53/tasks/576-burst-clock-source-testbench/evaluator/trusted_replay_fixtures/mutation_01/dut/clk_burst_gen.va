`include "constants.vams"
`include "disciplines.vams"

`default_transition 30p

// Outputs two consecutive CLK pulses every `div` input clock cycles.
// CLK_OUT mirrors CLK for cycles 0 and 1, then stays low until the period resets.
// RST_N (active-low reset) restarts the counter and re-enables the gate.

module clk_burst_gen (
    input  electrical CLK,
    input  electrical RST_N,
    output electrical CLK_OUT
);

parameter integer div = 8;   // burst period in CLK cycles (must be >= 3)
parameter real    vdd = 0.9;
parameter real    vth = 0.45;

integer counter_q;  // 0 .. div-1
integer gate_q;     // 1 = pass CLK through, 0 = hold low
integer clk_hi;     // tracks current CLK level for continuous output

analog begin
    @(initial_step) begin
        counter_q = 0;
        gate_q = 0;
        clk_hi = 0;
    end

    @(cross(V(CLK) - vth, +1)) begin
        counter_q = 0;
        gate_q = 0;
        clk_hi = 0;
    end

    V(CLK_OUT) <+ transition(0.0);
end
endmodule
