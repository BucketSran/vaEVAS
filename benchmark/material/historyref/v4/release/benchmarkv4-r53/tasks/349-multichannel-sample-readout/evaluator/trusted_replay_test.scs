simulator lang=spectre
global 0

ahdl_include "../submission/sample_mux_readout_top.va"
ahdl_include "../submission/sample_hold_bank.va"
ahdl_include "../submission/mux_controller.va"
ahdl_include "../submission/output_driver.va"

Vclk (clk 0) vsource type=pulse val0=0 val1=0.9 period=10n width=4n delay=5n rise=100p fall=100p
Vrst (rst 0) vsource type=pwl wave=[0 0.9 2n 0.9 2.1n 0 145n 0]
Vch0 (ch0 0) vsource type=pwl wave=[0 0.08 18n 0.08 18.1n 0.82 68n 0.82 68.1n 0.66 78n 0.66 78.1n 0.12 145n 0.12]
Vch1 (ch1 0) vsource type=pwl wave=[0 0.31 18n 0.31 18.1n 0.66 68n 0.66 68.1n 0.42 78n 0.42 78.1n 0.3 145n 0.3]
Vch2 (ch2 0) vsource type=pwl wave=[0 0.57 18n 0.57 18.1n 0.5 68n 0.5 68.1n 0.22 78n 0.22 78.1n 0.48 145n 0.48]
Vch3 (ch3 0) vsource type=pwl wave=[0 0.84 18n 0.84 18.1n 0.34 68n 0.34 68.1n 0.04 78n 0.04 78.1n 0.66 145n 0.66]
Vsample (sample 0) vsource type=pwl wave=[0 0 12n 0 12.1n 0.9 18n 0.9 18.1n 0 72n 0 72.1n 0.9 78n 0.9 78.1n 0 145n 0]
Vread (read 0) vsource type=pwl wave=[0 0 22n 0 22.1n 0.9 59n 0.9 59.1n 0 82n 0 82.1n 0.9 119n 0.9 119.1n 0 145n 0]
XDUT (ch0 ch1 ch2 ch3 clk rst sample read out ch_sel_1 ch_sel_0 valid) sample_mux_readout_top

tran tran stop=145n maxstep=100p
save ch0 ch1 ch2 ch3 clk rst sample read out ch_sel_1 ch_sel_0 valid
