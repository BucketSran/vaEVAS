simulator lang=spectre
global 0

ahdl_include "./dut/comparator_offset_calibration_loop.va"
ahdl_include "./dut/support/support_offset_comparator.va"

Vvdd (vdd 0) vsource dc=0.9
Vvss (vss 0) vsource dc=0.0
Vvos (vos_ref 0) vsource dc=0.023
Vclk (clk 0) vsource type=pulse val0=0 val1=0.9 delay=2n period=8n width=4n rise=100p fall=100p
// The public support comparator is mounted read-only from the declared support contract.
XLOOP (vdd vss clk dcmpp vinp vinn offset_est valid) comparator_offset_calibration_loop
XCMP (vdd vss vinp vinn vos_ref dcmpp) support_offset_comparator

simulatorOptions options evas_profile=balanced

tran tran stop=70n maxstep=20p
save vdd vss clk dcmpp vinp vinn offset_est valid vos_ref
