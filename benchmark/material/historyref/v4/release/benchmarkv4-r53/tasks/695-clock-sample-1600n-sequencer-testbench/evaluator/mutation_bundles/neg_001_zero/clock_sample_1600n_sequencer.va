`include "disciplines.vams"
        module clock_sample_1600n_sequencer(rst, s, nc, res, conv);
        output rst, s, nc, res, conv;
        electrical rst, s, nc, res, conv;

analog begin
    V(rst) <+ 0;
    V(s) <+ 0;
    V(nc) <+ 0;
    V(res) <+ 0;
    V(conv) <+ 0;
end
endmodule
