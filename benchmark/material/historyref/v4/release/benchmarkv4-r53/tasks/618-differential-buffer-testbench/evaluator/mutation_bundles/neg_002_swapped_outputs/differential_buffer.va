`include "disciplines.vams"
module differential_buffer (VINP, VINN, VOUTP, VOUTN);
input VINP, VINN; output VOUTP, VOUTN; electrical VINP, VINN, VOUTP, VOUTN;
analog begin
    V(VOUTP) <+ V(VINN);
    V(VOUTN) <+ V(VINP);
end
endmodule
