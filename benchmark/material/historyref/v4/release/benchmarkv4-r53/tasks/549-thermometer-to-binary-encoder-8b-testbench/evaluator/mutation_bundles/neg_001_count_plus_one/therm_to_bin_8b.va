`include "constants.vams"
`include "disciplines.vams"

module therm_to_bin_8b(
    input electrical [255:0] th,
    output electrical [7:0] b,
    output electrical valid
);
    parameter real vdd = 0.9;
    parameter real vth = 0.45;
    parameter real tr = 20p;

    integer count;
    integer valid_i;
    integer seen_low;
    genvar i;

    analog begin
        count = 0;
        valid_i = 1;
        seen_low = 0;
        for (i = 0; i < 256; i = i + 1) begin
            if (V(th[i]) > vth) begin
                if (seen_low != 0) valid_i = 0;
                count = count + 1;
            end else begin
                seen_low = 1;
            end
        end
        if (count > 255) valid_i = 0;
        if (valid_i != 0) count = count + 1;
        if ((valid_i == 0) || (count > 255)) count = 0;
        for (i = 0; i < 8; i = i + 1) begin
            V(b[i]) <+ transition((((count / (1 << i)) % 2) != 0) ? vdd : 0.0, 0, tr, tr);
        end
        V(valid) <+ transition((valid_i != 0) ? vdd : 0.0, 0, tr, tr);
    end
endmodule
