`include "disciplines.vams"
module subradix_dac10(vd9, vd8, vd7, vd6, vd5, vd4, vd3, vd2, vd1, vd0, vout);
input vd9, vd8, vd7, vd6, vd5, vd4, vd3, vd2, vd1, vd0;
output vout;
electrical vd9, vd8, vd7, vd6, vd5, vd4, vd3, vd2, vd1, vd0, vout;
analog begin
    V(vout) <+ 0.0;
end
endmodule
