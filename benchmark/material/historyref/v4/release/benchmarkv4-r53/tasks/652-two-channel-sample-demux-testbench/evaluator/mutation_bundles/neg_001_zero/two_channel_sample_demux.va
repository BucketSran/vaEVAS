`include "disciplines.vams"

module two_channel_sample_demux(samp1, samp2, clks1, clks2, vout);
input samp1, samp2, clks1, clks2;
output vout;
electrical samp1, samp2, clks1, clks2, vout;

analog begin
    V(vout) <+ 0;
end

endmodule
