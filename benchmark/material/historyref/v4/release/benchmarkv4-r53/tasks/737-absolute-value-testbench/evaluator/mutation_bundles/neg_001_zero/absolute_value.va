`include "disciplines.vams"
module absolute_value(sigin, sigout);
input sigin;
output sigout;
electrical sigin, sigout;
analog begin
    V(sigout) <+ 0.0;
end
endmodule
