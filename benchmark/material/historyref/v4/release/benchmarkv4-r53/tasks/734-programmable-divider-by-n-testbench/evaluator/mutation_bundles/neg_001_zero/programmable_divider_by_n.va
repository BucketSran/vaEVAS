`include "disciplines.vams"
module programmable_divider_by_n(clk, divctrl, out);
input clk, divctrl;
output out;
electrical clk, divctrl, out;
analog begin
    V(out) <+ 0.0;
end
endmodule
