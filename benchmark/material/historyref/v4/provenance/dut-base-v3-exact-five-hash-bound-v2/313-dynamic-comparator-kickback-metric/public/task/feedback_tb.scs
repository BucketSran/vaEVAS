simulator lang=spectre
global 0

ahdl_include "./dut/dynamic_comparator_kickback_metric.va"

Vvinp (vinp 0) vsource type=pwl wave=[0 0.40 8n 0.40 14n 0.52 23n 0.52 32n 0.78 44n 0.78 58n 0.42 80n 0.62]
Vvinn (vinn 0) vsource type=pwl wave=[0 0.50 8n 0.50 14n 0.48 23n 0.48 32n 0.24 44n 0.24 58n 0.58 80n 0.54]
Vclk (clk 0) vsource type=pulse val0=0 val1=0.9 period=6n width=2n delay=3n rise=60p fall=60p
Vrst (rst 0) vsource type=pwl wave=[0 0.9 2.1n 0.9 2.2n 0 50n 0 50.1n 0.9 53.5n 0.9 53.6n 0 80n 0]
Venable (enable 0) vsource type=pwl wave=[0 0 5n 0 5.1n 0.9 43n 0.9 43.1n 0 48n 0 48.1n 0.9 80n 0.9]
XDUT (vinp vinn clk rst enable decision kickback_metric valid) dynamic_comparator_kickback_metric

simulatorOptions options evas_profile=balanced

tran tran stop=80n maxstep=80p
save vinp vinn clk rst enable decision kickback_metric valid
