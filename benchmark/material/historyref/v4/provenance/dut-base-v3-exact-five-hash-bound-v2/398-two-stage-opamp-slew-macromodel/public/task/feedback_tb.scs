simulator lang=spectre
global 0

ahdl_include "./dut/two_stage_opamp_slew_macromodel.va"

Vvinp (vinp 0) vsource type=pwl wave=[0 0.47 18n 0.47 18.2n 0.58 42n 0.58 42.2n 0.35 70n 0.35 70.2n 0.43 102n 0.43]
Vvinn (vinn 0) vsource type=pwl wave=[0 0.43 102n 0.43]
Vclk (clk 0) vsource type=pwl wave=[0 0 9n 0 10n 0.9 12n 0.9 12.2n 0 20n 0.9 22n 0.9 22.2n 0 30n 0.9 32n 0.9 32.2n 0 40n 0.9 42n 0.9 42.2n 0 50n 0.9 52n 0.9 52.2n 0 60n 0.9 62n 0.9 62.2n 0 70n 0.9 72n 0.9 72.2n 0 80n 0.9 82n 0.9 82.2n 0 90n 0.9 92n 0.9 92.2n 0 102n 0]
Vrst (rst 0) vsource type=pwl wave=[0 0.9 3n 0.9 3.2n 0 102n 0]
Venable (enable 0) vsource type=pwl wave=[0 0 5n 0 5.2n 0.9 92n 0.9 92.2n 0 102n 0]
Vload_step (load_step 0) vsource type=pwl wave=[0 0.45 50n 0.45 50.2n 0.68 70n 0.68 70.2n 0.45 102n 0.45]
XDUT (vinp vinn clk rst enable load_step vout stage1_metric slew_metric clamp_flag settled) two_stage_opamp_slew_macromodel

simulatorOptions options evas_profile=balanced

tran tran stop=102n maxstep=200p
save vinp vinn clk rst enable load_step vout stage1_metric slew_metric clamp_flag settled
