// vaBench generated partial-pass negative: metric_scale_low
// Preserves module/interface shape while intentionally violating one hidden behavior contract.
`include "disciplines.vams"
module safe_analog_divider(signumer, sigdenom, sigout);
input signumer, sigdenom;
output sigout;
electrical signumer, sigdenom, sigout;
parameter real gain = 1.0;
parameter real min_sigdenom = 0.2;
real denominator;
analog begin
    denominator = V(sigdenom);
    if (abs(denominator) < min_sigdenom)
        denominator = (denominator > 0.0) ? min_sigdenom : -min_sigdenom;
    V(sigout) <+ (0.42 * (gain * V(signumer) / denominator));
end
endmodule
