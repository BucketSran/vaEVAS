simulator lang=spectre
global 0

ahdl_include "./dut/safe_analog_divider.va"

Vnum (signumer 0) vsource type=pwl wave=[0 -0.4 0.75n -0.4 0.80n 0.8 1.55n 0.8 1.60n 0.8 2.35n 0.8 2.40n -0.6 3.15n -0.6 3.20n 0.5 4.0n 0.5]
Vden (sigdenom 0) vsource type=pwl wave=[0 1.5 0.75n 1.5 0.80n 0 1.55n 0 1.60n 0.08 2.35n 0.08 2.40n -0.08 3.15n -0.08 3.20n -1.2 4.0n -1.2]
XDUT (signumer sigdenom sigout) safe_analog_divider

simulatorOptions options evas_profile=balanced

tran tran stop=3.8n maxstep=5p
save signumer sigdenom sigout
