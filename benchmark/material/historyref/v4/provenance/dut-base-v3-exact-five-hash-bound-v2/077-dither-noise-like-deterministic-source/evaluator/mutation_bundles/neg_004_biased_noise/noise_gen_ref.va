`include "constants.vams"
`include "disciplines.vams"

module noise_gen(vin_i, vout_o);
    input vin_i;
    output vout_o;
    electrical vin_i, vout_o;
    parameter real sigma = 0.01;
    parameter real dt = 0.5n;
    real noise, raw;
    integer sample_idx;
    analog begin
        @(initial_step) begin
            noise = 0.12;
            sample_idx = 0;
        end
        @(timer(0, dt)) begin
            sample_idx = sample_idx + 1;
            raw = sin(12.9898 * sample_idx)
                + 0.6 * sin(78.233 * sample_idx + 0.37)
                + 0.4 * sin(37.719 * sample_idx + 1.11);
            noise = 0.12 + sigma * raw / 1.232;
        end
        V(vout_o) <+ slew(V(vin_i) + noise, 0.9 / (dt/10), -0.9 / (dt/10));
    end
endmodule
