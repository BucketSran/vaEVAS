`include "constants.vams"
`include "disciplines.vams"

module noise_gen(vin_i, vout_o);
    input vin_i;
    output vout_o;
    electrical vin_i, vout_o;
    parameter real sigma = 0.01;
    parameter real dt = 0.5n;
    analog begin
        V(vout_o) <+ transition(0.0);
    end
endmodule
