`include "disciplines.vams"

module folded_flash_dac_4b(vd4, vd3, vd2, vd1, vout);
input vd4, vd3, vd2, vd1;
output vout;
electrical vd4, vd3, vd2, vd1, vout;
//

analog begin
    V(vout) <+ 0;
end

endmodule
