simulator lang=spectre
global 0

ahdl_include "./dut/sst_driver_macro.va"

Vclk (clk 0) vsource type=pulse val0=0 val1=0.9 period=9n width=1.8n delay=4.5n rise=50p fall=50p
Vrst (rst 0) vsource type=pwl wave=[0 0.9 3n 0.9 3.1n 0 160n 0]
Venable (enable 0) vsource type=pwl wave=[0 0 4n 0 4.1n 0.9 136n 0.9 136.1n 0 146n 0 146.1n 0.9 160n 0.9]
Vdata (data 0) vsource type=pwl wave=[0 0 8n 0.9 17n 0.9 17.1n 0 26n 0 26.1n 0.9 35n 0.9 35.1n 0 44n 0 44.1n 0 53n 0 53.1n 0.9 62n 0.9 62.1n 0.9 71n 0.9 71.1n 0 80n 0 80.1n 0.9 89n 0.9 89.1n 0 98n 0 98.1n 0.9 107n 0.9 107.1n 0 116n 0 116.1n 0.9 125n 0.9 125.1n 0 134n 0 134.1n 0 143n 0 143.1n 0.9 152n 0.9 152.1n 0.9 160n 0.9]
Vz_2 (z_2 0) vsource type=pwl wave=[0 0 8n 0.9 26n 0.9 26.1n 0 44n 0 44.1n 0.9 62n 0.9 62.1n 0 80n 0 80.1n 0.9 98n 0.9 98.1n 0 116n 0 116.1n 0.9 134n 0.9 134.1n 0 152n 0 152.1n 0.9 160n 0.9]
Vz_1 (z_1 0) vsource type=pwl wave=[0 0 8n 0.9 26n 0.9 26.1n 0.9 44n 0.9 44.1n 0 62n 0 62.1n 0 80n 0 80.1n 0.9 98n 0.9 98.1n 0.9 116n 0.9 116.1n 0 134n 0 134.1n 0 152n 0 152.1n 0.9 160n 0.9]
Vz_0 (z_0 0) vsource type=pwl wave=[0 0 8n 0.9 26n 0.9 26.1n 0 44n 0 44.1n 0 62n 0 62.1n 0.9 80n 0.9 80.1n 0 98n 0 98.1n 0.9 116n 0.9 116.1n 0.9 134n 0.9 134.1n 0 152n 0 152.1n 0.9 160n 0.9]

XDUT (data enable clk rst z_2 z_1 z_0 vout swing_metric z_metric) sst_driver_macro

simulatorOptions options evas_profile=balanced

tran tran stop=160n maxstep=100p
save data enable clk rst z_2 z_1 z_0 vout swing_metric z_metric
