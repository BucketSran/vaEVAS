`include "disciplines.vams"

module divide_by_8_9_switch(clkin, mc, out);
input clkin, mc;
output out;
electrical clkin, mc, out;
//

analog begin
    V(out) <+ 0;
end

endmodule
