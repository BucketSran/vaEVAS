`include "disciplines.vams"

module ideal_adc_out_7bits_scalar(din0, din1, din2, din3, din4, din5, din6, dout);
input din0, din1, din2, din3, din4, din5, din6;
output dout;
electrical din0, din1, din2, din3, din4, din5, din6, dout;

analog begin
    V(dout) <+ 0;
end

endmodule
