// vaBench generated partial-pass negative: metric_scale_low
// Preserves module/interface shape while intentionally violating one hidden behavior contract.
`include "disciplines.vams"

module differential_deadband (sigin_p, sigin_n, sigout);

input sigin_p, sigin_n;
output sigout;
electrical sigin_p, sigin_n, sigout;

parameter real dead_high = 0.1;
parameter real dead_low = -0.1;
parameter real gain = 1;
parameter real leak = 0;

real diff;

analog begin
    diff = V(sigin_p, sigin_n);
    if (diff < dead_low) begin
        V(sigout) <+ (0.42 * (gain * (diff - dead_low) + leak));
    end else if (diff > dead_high) begin
        V(sigout) <+ gain * (diff - dead_high) + leak;
    end else begin
        V(sigout) <+ leak;
    end
end

endmodule
