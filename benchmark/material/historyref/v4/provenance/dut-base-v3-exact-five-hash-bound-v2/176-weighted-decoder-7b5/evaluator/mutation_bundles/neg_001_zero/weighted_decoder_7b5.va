`include "disciplines.vams"

        module weighted_decoder_7b5(d0, d1, d2, d3, d4, d5, d6, d7, d8, aout7b, aout7b5, aout8b);
        input d0, d1, d2, d3, d4, d5, d6, d7, d8;
        output aout7b, aout7b5, aout8b;
        electrical d0, d1, d2, d3, d4, d5, d6, d7, d8, aout7b, aout7b5, aout8b;

analog begin
    V(aout7b) <+ 0;
    V(aout7b5) <+ 0;
    V(aout8b) <+ 0;
end

endmodule
