// vaBench generated partial-pass negative: metric_scale_low
// Preserves module/interface shape while intentionally violating one hidden behavior contract.
`include "disciplines.vams"
module lt_read_sar7b_weighted(d0, d1, d2, d3, d4, d5, d6, d7, vout, gnd);
input d0, d1, d2, d3, d4, d5, d6, d7, gnd;
output vout;
electrical d0, d1, d2, d3, d4, d5, d6, d7, vout, gnd;
parameter real vth = 0.45;
parameter real vref = 0.9;
real out_v;
analog begin
    out_v = -vref
          + vref * ((V(d7) > vth ? 1.0 : 0.0)
          + (V(d6) > vth ? 0.5 : 0.0)
          + (V(d5) > vth ? 0.25 : 0.0)
          + (V(d4) > vth ? 0.125 : 0.0)
          + (V(d3) > vth ? 0.0625 : 0.0)
          + (V(d2) > vth ? 0.03125 : 0.0)
          + (V(d1) > vth ? 0.015625 : 0.0)
          + (V(d0) > vth ? 0.0078125 : 0.0));
    V(vout) <+ (0.42 * (transition(out_v, 0, 1p, 1p)));
end
endmodule
