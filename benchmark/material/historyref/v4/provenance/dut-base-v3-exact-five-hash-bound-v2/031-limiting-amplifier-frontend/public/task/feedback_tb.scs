simulator lang=spectre
global 0

ahdl_include "./dut/limiting_amplifier_frontend.va"

Vclk (clk 0) vsource type=pulse val0=0 val1=0.9 period=2n width=1n rise=50p fall=50p
Vrst (rst 0) vsource type=pwl wave=[0 0.9 2n 0.9 2.1n 0 61.8n 0 61.9n 0.9 64.2n 0.9 64.3n 0 80n 0]
Vvin (vin 0) vsource type=pwl wave=[0 0.45 7.9n 0.45 8n 0.50 21.9n 0.50 22n 0.78 43.9n 0.78 44n 0.18 63.9n 0.18 64n 0.56 67.9n 0.56 68n 1.50 71.9n 1.50 72n -0.65 80n -0.65]
XDUT (clk rst vin out metric) limiting_amplifier_frontend

simulatorOptions options evas_profile=balanced

tran tran stop=80n maxstep=0.5n
save clk rst vin out metric
