`include "disciplines.vams"

module differential_common_mode_window_monitor(vip, vin, vcm_ref, en, diff_ok, cm_ok, valid, diff_metric, cm_metric);
input vip, vin, vcm_ref, en;
output diff_ok, cm_ok, valid, diff_metric, cm_metric;
electrical vip, vin, vcm_ref, en, diff_ok, cm_ok, valid, diff_metric, cm_metric;

parameter real vth = 0.45;
parameter real vhi = 0.9;
parameter real diff_max = 0.30;
parameter real diff_fullscale = 0.45;
parameter real cm_tol = 0.080;
parameter real cm_fullscale = 0.160;
parameter real tr = 50p;

real vip_err;
real vin_err;
real diff_ok_v;
real cm_ok_v;
real valid_v;

analog begin
    vip_err = abs(V(vip) - V(vcm_ref));
    vin_err = abs(V(vin) - V(vcm_ref));
    diff_ok_v = ((V(en) > vth) && (vip_err <= diff_max) && (vin_err <= diff_max)) ? vhi : 0.0;
    cm_ok_v = ((V(en) > vth) && (vip_err <= cm_tol) && (vin_err <= cm_tol)) ? vhi : 0.0;
    valid_v = ((diff_ok_v > 0.45) && (cm_ok_v > 0.45)) ? vhi : 0.0;

    V(diff_ok) <+ diff_ok_v;
    V(cm_ok) <+ cm_ok_v;
    V(valid) <+ valid_v;
    V(diff_metric) <+ vhi * (vip_err + vin_err) / (2.0 * diff_fullscale);
    V(cm_metric) <+ vhi * (vip_err + vin_err) / (2.0 * cm_fullscale);
end
endmodule
