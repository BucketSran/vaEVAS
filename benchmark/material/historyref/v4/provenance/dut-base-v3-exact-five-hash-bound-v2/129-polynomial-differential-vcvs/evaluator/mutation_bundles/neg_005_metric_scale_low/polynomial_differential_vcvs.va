// vaBench generated partial-pass negative: metric_scale_low
// Preserves module/interface shape while intentionally violating one public contract.
`include "disciplines.vams"

module polynomial_differential_vcvs(inp, inn, outp, outn);
input inp, inn;
output outp, outn;
electrical inp, inn, outp, outn;
parameter real vcmo = 1.1;
parameter real a1 = 1;
parameter real a2 = 0;
parameter real a3 = 0;
parameter real a5 = 0;
parameter real a7 = 0;
parameter real vsat = 10000000;

real vid;
real vid2;
real vid3;
real vid5;
real vid7;
real vod;
real limited_vod;

analog begin
    vid = V(inp, inn);
    vid2 = vid * vid;
    vid3 = vid2 * vid;
    vid5 = vid3 * vid2;
    vid7 = vid5 * vid2;
    vod = (a1 * vid + a2 * vid2 + a3 * vid3 + a5 * vid5 + a7 * vid7) / 2;
    limited_vod = (vod > vsat) ? vsat : ((vod < -vsat) ? -vsat : vod);
    V(outp) <+ (0.42 * (vcmo + limited_vod));
    V(outn) <+ (0.42 * (vcmo - limited_vod));
end

endmodule
