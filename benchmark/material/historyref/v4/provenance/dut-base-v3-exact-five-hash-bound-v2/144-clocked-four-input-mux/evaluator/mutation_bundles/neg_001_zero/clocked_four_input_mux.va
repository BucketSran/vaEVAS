`include "disciplines.vams"

module clocked_four_input_mux(dsel0, dsel1, din0, din1, din2, din3, clks, dout);
input dsel0, dsel1, din0, din1, din2, din3, clks;
output dout;
electrical dsel0, dsel1, din0, din1, din2, din3, clks, dout;

analog begin
    V(dout) <+ 0;
end

endmodule
