simulator lang=spectre
global 0

ahdl_include "./dut/interleaved_adc_skew_monitor_top.va"
ahdl_include "./dut/sample_pair_latch.va"
ahdl_include "./dut/skew_metric_core.va"

Vvin_a (vin_a 0) vsource type=pwl wave=[0 0.42 8n 0.42 16n 0.78 28n 0.78 38n 0.32 52n 0.32 80n 0.70]
Vvin_b (vin_b 0) vsource type=pwl wave=[0 0.40 8n 0.40 16n 0.62 28n 0.62 38n 0.50 52n 0.50 80n 0.46]
Vclk_a (clk_a 0) vsource type=pulse val0=0 val1=0.9 period=6n width=2n delay=2n rise=60p fall=60p
Vclk_b (clk_b 0) vsource type=pulse val0=0 val1=0.9 period=6n width=2n delay=3.3n rise=60p fall=60p
Vrst (rst 0) vsource type=pwl wave=[0 0.9 2.1n 0.9 2.2n 0 50n 0 50.1n 0.9 53.5n 0.9 53.6n 0 80n 0]
Venable (enable 0) vsource type=pwl wave=[0 0 5n 0 5.1n 0.9 43n 0.9 43.1n 0 48n 0 48.1n 0.9 80n 0.9]
XDUT (vin_a vin_b clk_a clk_b rst enable skew_metric magnitude_metric alarm) interleaved_adc_skew_monitor_top

simulatorOptions options evas_profile=balanced

tran tran stop=80n maxstep=80p
save vin_a vin_b clk_a clk_b rst enable skew_metric magnitude_metric alarm
