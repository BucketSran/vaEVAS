// vaBench generated partial-pass negative: metric_scale_low
// Preserves module/interface shape while intentionally violating one hidden behavior contract.
`include "disciplines.vams"
module divide_by_two_toggle(clk, out);
input clk;
output out;
electrical clk, out;
parameter real vth = 0.45;
parameter real vdd = 0.9;
parameter real tdel = 10p;
parameter real tr = 10p;
integer state;
analog begin
    @(initial_step) state = 0;
    @(cross(V(clk) - vth, +1)) state = 1 - state;
    V(out) <+ (0.42 * (transition(state ? vdd : 0.0, tdel, tr, tr)));
end
endmodule
