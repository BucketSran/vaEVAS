simulator lang=spectre
global 0

ahdl_include "./dut/tdc_measurement_top.va"
ahdl_include "./dut/edge_detector.va"
ahdl_include "./dut/interval_counter.va"
ahdl_include "./dut/binary_encoder.va"
ahdl_include "./dut/valid_latch.va"

Vclk (clk 0) vsource type=pulse val0=0 val1=0.9 period=0.1n width=0.04n delay=0.08n rise=10p fall=10p
Vrst (rst 0) vsource type=pwl wave=[0 0.9 0.10n 0.9 0.12n 0 35n 0]
Vstart (start 0) vsource type=pwl wave=[0 0 0.64n 0 0.66n 0.9 0.72n 0.9 0.74n 0 3.04n 0 3.06n 0.9 3.12n 0.9 3.14n 0 6.04n 0 6.06n 0.9 6.12n 0.9 6.14n 0 35n 0]
Vstop (stop 0) vsource type=pwl wave=[0 0 1.83n 0 1.85n 0.9 1.91n 0.9 1.93n 0 5.43n 0 5.45n 0.9 5.51n 0.9 5.53n 0 35n 0]
XDUT (start stop clk rst code_7 code_6 code_5 code_4 code_3 code_2 code_1 code_0 valid overflow) tdc_measurement_top

simulatorOptions options evas_profile=balanced

tran tran stop=35n maxstep=50p
save start stop clk rst code_7 code_6 code_5 code_4 code_3 code_2 code_1 code_0 valid overflow
