`include "constants.vams"
`include "disciplines.vams"

module prbs7_ref(clk, rst_n, en, serial_out, state_0, state_1, state_2, state_3, state_4, state_5, state_6);
    input clk, rst_n, en;
    output serial_out, state_0, state_1, state_2, state_3, state_4, state_5, state_6;
    electrical clk, rst_n, en, serial_out, state_0, state_1, state_2, state_3, state_4, state_5, state_6;
    parameter real vdd = 0.9;
    parameter real vth = 0.45;
    parameter real trf = 10p;
    parameter real td = 0p;
    parameter integer seed = 127;
    analog begin
        V(serial_out) <+ transition(0.0, td, trf, trf);
        V(state_0) <+ transition(0.0, td, trf, trf);
        V(state_1) <+ transition(0.0, td, trf, trf);
        V(state_2) <+ transition(0.0, td, trf, trf);
        V(state_3) <+ transition(0.0, td, trf, trf);
        V(state_4) <+ transition(0.0, td, trf, trf);
        V(state_5) <+ transition(0.0, td, trf, trf);
        V(state_6) <+ transition(0.0, td, trf, trf);
    end
endmodule
