`include "disciplines.vams"

module max_detector_hold (vin, vout);

input vin;
output vout;
electrical vin, vout;

analog begin
    V(vout) <+ 0;
end

endmodule
