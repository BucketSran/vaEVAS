simulator lang=spectre
global 0

ahdl_include "./dut/flash_adc_threshold_taps.va"

Vclk (clk 0) vsource type=pwl wave=[0 0 2n 0 2.1n 0.9 2.5n 0.9 2.6n 0 12n 0 12.1n 0.9 12.5n 0.9 12.6n 0 22n 0 22.1n 0.9 22.5n 0.9 22.6n 0 32n 0 32.1n 0.9 32.5n 0.9 32.6n 0 42n 0 42.1n 0.9 42.5n 0.9 42.6n 0 48n 0]
Vvin (vin 0) vsource type=pwl wave=[0 -0.13 4.95n -0.13 5n 0.13 6.95n 0.13 7n -0.13 8n -0.13 8.1n -0.05 18n -0.05 18.1n 0.02 28n 0.02 28.1n 0.09 38n 0.09 38.1n 0.13 48n 0.13]
XDUT (vin clk dout0 dout1 dout2 dout3 dout4 dout5 dout6) flash_adc_threshold_taps

simulatorOptions options evas_profile=balanced

tran tran stop=46n maxstep=20p
save clk dout0 dout1 dout2 dout3 dout4 dout5 dout6 vin
