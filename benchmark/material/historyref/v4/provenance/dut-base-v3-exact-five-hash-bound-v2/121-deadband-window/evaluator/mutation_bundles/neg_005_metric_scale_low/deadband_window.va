// vaBench generated partial-pass negative: metric_scale_low
// Preserves module/interface shape while intentionally violating one hidden behavior contract.
`include "disciplines.vams"

module deadband_window (sigin, sigout);

input sigin;
output sigout;
electrical sigin, sigout;

parameter real dead_high = 0.1;
parameter real dead_low = -0.1;

analog begin
    if (V(sigin) < dead_low) begin
        V(sigout) <+ (0.42 * (V(sigin) - dead_low));
    end else if (V(sigin) > dead_high) begin
        V(sigout) <+ V(sigin) - dead_high;
    end else begin
        V(sigout) <+ 0;
    end
end

endmodule
