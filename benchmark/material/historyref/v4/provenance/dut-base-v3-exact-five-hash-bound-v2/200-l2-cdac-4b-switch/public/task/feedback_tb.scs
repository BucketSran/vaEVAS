simulator lang=spectre
global 0

ahdl_include "./dut/l2_cdac_4b_switch.va"

Vrdy (rdy 0) vsource type=pulse val0=0 val1=1.1 delay=0.2n period=1n width=0.4n rise=20p fall=20p
Vd1 (din1 0) vsource type=pwl wave=[0 0 2n 0 2.05n 0 3n 0 3.05n 1.1 4n 1.1]
Vd2 (din2 0) vsource type=pwl wave=[0 0 2n 0 2.05n 1.1 3n 1.1 3.05n 1.1 4n 1.1]
Vd3 (din3 0) vsource type=pwl wave=[0 0 2n 0 2.05n 0 3n 0 3.05n 1.1 4n 1.1]
Vd4 (din4 0) vsource type=pwl wave=[0 0 2n 0 2.05n 1.1 3n 1.1 3.05n 1.1 4n 1.1]
XDUT (din1 din2 din3 din4 rdy aout) l2_cdac_4b_switch

simulatorOptions options evas_profile=balanced

tran tran stop=2.8n maxstep=10p
save aout din1 din2 din3 din4 rdy
