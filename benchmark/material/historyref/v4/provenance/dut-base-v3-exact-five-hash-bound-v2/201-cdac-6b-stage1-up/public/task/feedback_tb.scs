simulator lang=spectre
global 0

ahdl_include "./dut/cdac_6b_stage1_up.va"

Vvin (vin 0) vsource type=pwl wave=[0 0.2 5.8n 0.2 5.9n -0.1 7.2n -0.1]
Vclks (clks 0) vsource type=pwl wave=[0 0 0.10n 0 0.12n 1 0.80n 1 0.82n 0 1.05n 0 1.07n 1 6.30n 1 6.32n 0 7.2n 0]
Vd5 (dctrl5 0) vsource type=pulse val0=0 val1=1 delay=1.2n period=20n width=8n rise=20p fall=20p
Vd4 (dctrl4 0) vsource type=pulse val0=0 val1=1 delay=1.8n period=20n width=8n rise=20p fall=20p
Vd3 (dctrl3 0) vsource type=pulse val0=0 val1=1 delay=2.4n period=20n width=8n rise=20p fall=20p
Vd2 (dctrl2 0) vsource type=pulse val0=0 val1=1 delay=3.0n period=20n width=8n rise=20p fall=20p
Vd1 (dctrl1 0) vsource type=pulse val0=0 val1=1 delay=3.6n period=20n width=8n rise=20p fall=20p
Vd0 (dctrl0 0) vsource type=pulse val0=0 val1=1 delay=4.2n period=20n width=8n rise=20p fall=20p
XDUT (vin clks dctrl0 dctrl1 dctrl2 dctrl3 dctrl4 dctrl5 vres) cdac_6b_stage1_up

simulatorOptions options evas_profile=balanced

tran tran stop=7.0n maxstep=10p
save vin clks dctrl0 dctrl1 dctrl2 dctrl3 dctrl4 dctrl5 vres
