simulator lang=spectre
global 0

ahdl_include "./dut/polyphase_quadrature_filter.va"

Vvin (vin 0) vsource type=pwl wave=[0 0.45 16n 0.45 16.2n 0.2 42n 0.2 42.2n 0.76 68n 0.76 68.2n 0.35 92n 0.35]
Vclk (clk 0) vsource type=pwl wave=[0 0 9n 0 10n 0.9 12n 0.9 12.2n 0 20n 0.9 22n 0.9 22.2n 0 30n 0.9 32n 0.9 32.2n 0 40n 0.9 42n 0.9 42.2n 0 50n 0.9 52n 0.9 52.2n 0 60n 0.9 62n 0.9 62.2n 0 70n 0.9 72n 0.9 72.2n 0 80n 0.9 82n 0.9 82.2n 0 92n 0]
Vrst (rst 0) vsource type=pwl wave=[0 0.9 3n 0.9 3.2n 0 92n 0]
Venable (enable 0) vsource type=pwl wave=[0 0 5n 0 5.2n 0.9 82n 0.9 82.2n 0 92n 0]
XDUT (vin clk rst enable i_out q_out amp_metric phase_metric valid) polyphase_quadrature_filter

simulatorOptions options evas_profile=balanced

tran tran stop=100n maxstep=100p
save vin clk rst enable i_out q_out amp_metric phase_metric valid
