`include "constants.vams"
`include "disciplines.vams"

module quad_corr_top(i_in, q_in, clk, rst, cal_en, i_out, q_out, gain_code_3, gain_code_2, gain_code_1, gain_code_0, phase_code_3, phase_code_2, phase_code_1, phase_code_0, error_metric, locked);
    input i_in, q_in, clk, rst, cal_en;
    output i_out, q_out, gain_code_3, gain_code_2, gain_code_1, gain_code_0;
    output phase_code_3, phase_code_2, phase_code_1, phase_code_0, error_metric, locked;
    electrical i_in, q_in, clk, rst, cal_en, i_out, q_out;
    electrical gain_code_3, gain_code_2, gain_code_1, gain_code_0;
    electrical phase_code_3, phase_code_2, phase_code_1, phase_code_0, error_metric, locked;

    parameter real vdd = 0.9;
    parameter real vss = 0.0;
    parameter real vcm = 0.45;
    parameter real vth = 0.45;
    parameter real trim_lsb = 10e-3;
    parameter real error_tol = 15e-3;
    parameter real tr = 200p from (0:inf);

    gain_trim #(.vdd(vdd), .vss(vss), .vcm(vcm), .vth(vth), .trim_lsb(trim_lsb), .error_tol(error_tol), .tr(tr))
        u_gain(i_in, q_in, clk, rst, cal_en, gain_code_3, gain_code_2, gain_code_1, gain_code_0);
    skew_estimator #(.vdd(vdd), .vss(vss), .vcm(vcm), .vth(vth), .trim_lsb(trim_lsb), .error_tol(error_tol), .tr(tr))
        u_skew(i_in, q_in, clk, rst, cal_en, phase_code_3, phase_code_2, phase_code_1, phase_code_0, error_metric, locked);
    corrector #(.vdd(vdd), .vss(vss), .vcm(vcm), .vth(vth), .trim_lsb(trim_lsb), .tr(tr))
        u_corr(i_in, q_in, rst, gain_code_3, gain_code_2, gain_code_1, gain_code_0, phase_code_3, phase_code_2, phase_code_1, phase_code_0, i_out, q_out);
endmodule
