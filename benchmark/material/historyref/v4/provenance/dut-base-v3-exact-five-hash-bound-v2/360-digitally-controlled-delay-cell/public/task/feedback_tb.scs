simulator lang=spectre
global 0

ahdl_include "./dut/digitally_controlled_delay_cell.va"

Vinclk (in_clk 0) vsource type=pulse val0=0 val1=0.9 delay=5n period=10n width=4n rise=20p fall=20p
Vrst (rst 0) vsource type=pwl wave=[0 0.9 1.2n 0.9 1.3n 0 132n 0 132.1n 0.9 137n 0.9 137.1n 0 160n 0]
Vload (load 0) vsource type=pwl wave=[0 0 2n 0 2.02n 0.9 2.4n 0.9 2.42n 0 31n 0 31.02n 0.9 31.4n 0.9 31.42n 0 65n 0 65.02n 0.9 65.4n 0.9 65.42n 0 101n 0 101.02n 0.9 101.4n 0.9 101.42n 0 160n 0]
Vcode5 (code_5 0) vsource type=pwl wave=[0 0 64n 0 64.1n 0.9 100n 0.9 100.1n 0 160n 0]
Vcode4 (code_4 0) vsource type=pwl wave=[0 0 30n 0 30.1n 0.9 64n 0.9 64.1n 0 100n 0 100.1n 0.9 160n 0.9]
Vcode3 (code_3 0) vsource type=pwl wave=[0 0 30n 0 30.1n 0.9 100n 0.9 100.1n 0 160n 0]
Vcode2 (code_2 0) vsource type=pwl wave=[0 0 64n 0 64.1n 0.9 100n 0.9 100.1n 0 160n 0]
Vcode1 (code_1 0) vsource type=pwl wave=[0 0 30n 0 30.1n 0.9 64n 0.9 64.1n 0 160n 0]
Vcode0 (code_0 0) vsource type=pwl wave=[0 0 64n 0 64.1n 0.9 160n 0.9]
XDUT (in_clk load rst code_5 code_4 code_3 code_2 code_1 code_0 out_clk delay_metric valid) digitally_controlled_delay_cell

simulatorOptions options evas_profile=balanced

tran tran stop=160n maxstep=5p
save in_clk load rst code_5 code_4 code_3 code_2 code_1 code_0 out_clk delay_metric valid
