simulator lang=spectre
global 0

ahdl_include "./dut/bin2ther_2b.va"

Vdd (vdd 0) vsource type=pwl wave=[0 0.9 1.60n 0.9 1.65n 1.2 2.70n 1.2 2.75n 0.7 4n 0.7]
Vgnd (gnd 0) vsource dc=0
Vb0 (b0 0) vsource type=pwl wave=[0 0 1n 0 1.05n 0.9 2n 0.9 2.05n 0 3n 0 3.05n 0.4 4n 0.4]
Vb1 (b1 0) vsource type=pwl wave=[0 0 2n 0 2.05n 0.9 4n 0.9]
XDUT (vdd gnd b1 b0 t0 t1 t2) bin2ther_2b

simulatorOptions options evas_profile=balanced

tran tran stop=3.8n maxstep=5p
save vdd gnd b1 b0 t0 t1 t2
