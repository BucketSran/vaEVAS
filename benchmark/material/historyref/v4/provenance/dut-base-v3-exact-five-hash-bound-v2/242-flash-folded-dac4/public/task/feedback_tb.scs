simulator lang=spectre
global 0

ahdl_include "./dut/flash_folded_dac4.va"

Vd4 (vd4 0) vsource type=pwl wave=[0 0 0.8n 0 0.85n 0 1.6n 0 1.65n 0.9 2.4n 0.9 2.45n 0.9 3.2n 0.9]
Vd3 (vd3 0) vsource type=pwl wave=[0 0 0.8n 0 0.85n 0.9 1.6n 0.9 1.65n 0 2.4n 0 2.45n 0.9 3.2n 0.9]
Vd2 (vd2 0) vsource type=pwl wave=[0 0 0.8n 0 0.85n 0 1.6n 0 1.65n 0.9 2.4n 0.9 2.45n 0.9 3.2n 0.9]
Vd1 (vd1 0) vsource type=pwl wave=[0 0 0.8n 0 0.85n 0 1.6n 0 1.65n 0 2.4n 0 2.45n 0.9 3.2n 0.9]
XDUT (vd4 vd3 vd2 vd1 vout) flash_folded_dac4

simulatorOptions options evas_profile=balanced

tran tran stop=3.0n maxstep=5p
save vd1 vd2 vd3 vd4 vout
