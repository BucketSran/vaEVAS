simulator lang=spectre
global 0

ahdl_include "./dut/reference_ladder_buffered_taps.va"

Vhi (vref_hi 0) vsource type=pwl wave=[0 0.85 12n 0.85 12.2n 0.62 28n 0.62 28.2n 1.05 50n 1.05 50.2n 0.20 90n 0.20]
Vlo (vref_lo 0) vsource type=pwl wave=[0 0.10 12n 0.10 12.2n 0.78 28n 0.78 28.2n -0.10 50n -0.10 50.2n 0.70 90n 0.70]
Ven (enable 0) vsource type=pwl wave=[0 0 4n 0 4.2n 0.9 66n 0.9 66.2n 0 90n 0]
Vrst (rst 0) vsource type=pwl wave=[0 0.9 3n 0.9 3.2n 0 40n 0 40.2n 0.9 44n 0.9 44.2n 0 90n 0]
XDUT (vref_hi vref_lo enable rst tap0 tap1 tap2 tap3 monotonic_ok) reference_ladder_buffered_taps

simulatorOptions options evas_profile=balanced

tran tran stop=72n maxstep=200p
save vref_hi vref_lo enable rst tap0 tap1 tap2 tap3 monotonic_ok
