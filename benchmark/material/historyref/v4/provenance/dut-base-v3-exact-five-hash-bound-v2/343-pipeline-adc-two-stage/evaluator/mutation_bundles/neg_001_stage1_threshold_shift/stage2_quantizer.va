`include "constants.vams"
`include "disciplines.vams"

module stage2_quantizer(residue_i, clk, rst, valid_i, bit_1, bit_0, valid_o);
input residue_i, clk, rst, valid_i;
output bit_1, bit_0, valid_o;
electrical residue_i, clk, rst, valid_i, bit_1, bit_0, valid_o;

parameter real vdd = 0.9;
parameter real vss = 0.0;
parameter real vref = 0.9;
parameter real vth = 0.45;
parameter real tr = 200p;

integer code;
real span, x, b1, b0, valid_level;

analog begin
    @(initial_step) begin code = 0; valid_level = vss; end
    @(cross(V(rst) - vth, +1)) begin code = 0; valid_level = vss; end
    @(cross(V(clk) - vth, +1)) begin
        if (V(rst) > vth) begin
            code = 0; valid_level = vss;
        end else if (V(valid_i) > vth) begin
            span = vref - vss;
            x = V(residue_i);
            if (x < vss) x = vss;
            if (x > vref) x = vref;
            if (x >= vref) code = 3;
            else if (x < vss + span * 0.25) code = 0;
            else if (x < vss + span * 0.50) code = 1;
            else if (x < vss + span * 0.75) code = 2;
            else code = 3;
            valid_level = vdd;
        end else begin
            valid_level = vss;
        end
    end
    b1 = (code >= 2) ? vdd : vss;
    b0 = ((code == 1) || (code == 3)) ? vdd : vss;
    V(bit_1) <+ transition(b1, 0, tr, tr);
    V(bit_0) <+ transition(b0, 0, tr, tr);
    V(valid_o) <+ transition(valid_level, 0, tr, tr);
end
endmodule
