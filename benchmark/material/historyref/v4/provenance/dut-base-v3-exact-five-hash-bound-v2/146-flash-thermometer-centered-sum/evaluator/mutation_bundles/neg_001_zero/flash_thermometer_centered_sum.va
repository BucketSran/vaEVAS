`include "disciplines.vams"

module flash_thermometer_centered_sum(b0, b1, b2, b3, b4, b5, b6, b7, dout);
input b0, b1, b2, b3, b4, b5, b6, b7;
output dout;
electrical b0, b1, b2, b3, b4, b5, b6, b7, dout;

analog begin
    V(dout) <+ 0;
end

endmodule
