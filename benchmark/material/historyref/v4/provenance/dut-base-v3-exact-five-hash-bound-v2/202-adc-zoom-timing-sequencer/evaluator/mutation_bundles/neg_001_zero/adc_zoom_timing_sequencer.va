`include "disciplines.vams"
        module adc_zoom_timing_sequencer(rst, s, sar, res, intg, clk_sar, zoom, clk_zoom, rst_zoom);
        output rst, s, sar, res, intg, clk_sar, zoom, clk_zoom, rst_zoom;
        electrical rst, s, sar, res, intg, clk_sar, zoom, clk_zoom, rst_zoom;

analog begin
    V(rst) <+ 0;
    V(s) <+ 0;
    V(sar) <+ 0;
    V(res) <+ 0;
    V(intg) <+ 0;
    V(clk_sar) <+ 0;
    V(zoom) <+ 0;
    V(clk_zoom) <+ 0;
    V(rst_zoom) <+ 0;
end
endmodule
