`include "disciplines.vams"

module dynamic_supply_level_driver(din, vdd, vss, out);
input din, vdd, vss;
output out;
electrical din, vdd, vss, out;
parameter real tr = 40p;
real target_v;
analog begin
    target_v = (V(din) > 0.45) ? 0.9 : 0.0;
    V(out) <+ target_v;
end
endmodule
