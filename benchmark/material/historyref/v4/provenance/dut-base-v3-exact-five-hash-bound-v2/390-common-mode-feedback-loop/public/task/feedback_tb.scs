simulator lang=spectre
global 0

ahdl_include "./dut/cmfb_loop_top.va"
ahdl_include "./dut/cm_sensor.va"
ahdl_include "./dut/trim_controller.va"
ahdl_include "./dut/output_balancer.va"

Vclk (clk 0) vsource type=pulse val0=0 val1=0.9 period=5n width=2.5n delay=1.2n rise=60p fall=60p
Vrst (rst 0) vsource type=pwl wave=[0 0.9 2.5n 0.9 2.6n 0 96n 0]
Ven (enable 0) vsource type=pwl wave=[0 0 3.5n 0 3.6n 0.9 72n 0.9 72.1n 0 79n 0 79.1n 0.9 96n 0.9]
Vvop (vop_in 0) vsource type=pwl wave=[0 0.56 6n 0.56 6.1n 0.62 54n 0.62 54.1n 0.58 96n 0.58]
Vvon (von_in 0) vsource type=pwl wave=[0 0.34 6n 0.34 6.1n 0.40 54n 0.40 54.1n 0.36 96n 0.36]
XDUT (vop_in von_in clk rst enable vop_out von_out trim_2 trim_1 trim_0 cm_error locked) cmfb_loop_top

simulatorOptions options evas_profile=balanced

tran tran stop=96n maxstep=80p
save vop_in von_in clk rst enable vop_out von_out trim_2 trim_1 trim_0 cm_error locked
