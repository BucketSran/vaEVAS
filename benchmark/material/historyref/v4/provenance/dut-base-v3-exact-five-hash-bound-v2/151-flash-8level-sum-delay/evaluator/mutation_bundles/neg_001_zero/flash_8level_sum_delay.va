`include "disciplines.vams"

module flash_8level_sum_delay(vip, vim, clks, reset, refp, refn, doutsum, doutsumdelay);
input vip, vim, clks, reset, refp, refn;
output doutsum, doutsumdelay;
electrical vip, vim, clks, reset, refp, refn, doutsum, doutsumdelay;

analog begin
    V(doutsum) <+ 0;
    V(doutsumdelay) <+ 0;
end

endmodule
