`include "disciplines.vams"

module l2_cdac_4b_residue(vin, clks, dctrl1, dctrl2, dctrl3, vres);
input vin, clks, dctrl1, dctrl2, dctrl3;
output vres;
electrical vin, clks, dctrl1, dctrl2, dctrl3, vres;

analog begin
    V(vres) <+ 0;
end

endmodule
