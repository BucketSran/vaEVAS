simulator lang=spectre
global 0

ahdl_include "./dut/l2_cdac_4b_residue.va"

Vvin (vin 0) vsource type=pwl wave=[0 0.1 11.95n 0.1 12n -0.2 13.25n -0.2 13.30n 0.3]
Vclks (clks 0) vsource type=pwl wave=[0 0 1n 0 1.05n 1.0 1.50n 1.0 1.55n 0 13n 0 13.05n 1.0 13.50n 1.0 13.55n 0]
Vdctrl3 (dctrl3 0) vsource type=pwl wave=[0 0 3n 0 3.05n 1 3.35n 1 3.40n 0]
Vdctrl2 (dctrl2 0) vsource type=pwl wave=[0 0 5n 0 5.05n 1 5.35n 1 5.40n 0 15n 0 15.05n 1 15.35n 1 15.40n 0]
Vdctrl1 (dctrl1 0) vsource type=pwl wave=[0 0 7n 0 7.05n 1 7.35n 1 7.40n 0]
XDUT (vin clks dctrl1 dctrl2 dctrl3 vres) l2_cdac_4b_residue

simulatorOptions options evas_profile=balanced

tran tran stop=18n maxstep=20p
save vin clks dctrl1 dctrl2 dctrl3 vres
