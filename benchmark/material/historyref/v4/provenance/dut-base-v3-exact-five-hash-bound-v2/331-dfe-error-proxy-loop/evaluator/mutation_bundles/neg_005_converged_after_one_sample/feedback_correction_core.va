`include "constants.vams"
`include "disciplines.vams"

module feedback_correction_core(sample_in, decision_clk, rst, enable, hist_1, hist_0, tap_1, tap_0, corrected_out, error_metric, converged);
    inout sample_in, decision_clk, rst, enable, hist_1, hist_0, tap_1, tap_0, corrected_out, error_metric, converged;
    electrical sample_in, decision_clk, rst, enable, hist_1, hist_0, tap_1, tap_0, corrected_out, error_metric, converged;

    parameter real vdd = 0.9;
    parameter real vss = 0.0;
    parameter real vcm = 0.45;
    parameter real vth = 0.45;
    parameter real tr = 200p from (0:inf);
    parameter real residual_tol = 35e-3 from [0:inf);

    real tap1_weight;
    real tap0_weight;
    real residual;
    integer good_count;
    integer premature_converged;

    analog function real absval;
        input x;
        real x;
        begin
            absval = (x < 0.0) ? -x : x;
        end
    endfunction

    analog function real clamp_rail;
        input x;
        real x;
        begin
            if (x < vss) clamp_rail = vss;
            else if (x > vdd) clamp_rail = vdd;
            else clamp_rail = x;
        end
    endfunction

    analog function real sign_from_voltage;
        input x;
        real x;
        begin
            if (x > vcm + 0.1) sign_from_voltage = 1.0;
            else if (x < vcm - 0.1) sign_from_voltage = -1.0;
            else sign_from_voltage = 0.0;
        end
    endfunction

    analog begin
        @(initial_step) begin
            tap1_weight = 0.0;
            tap0_weight = 0.0;
            residual = 0.0;
            good_count = 0;
            premature_converged = 0;
        end

        @(cross(V(rst) - vth, +1) or cross(V(enable) - vth, -1)) begin
            tap1_weight = 0.0;
            tap0_weight = 0.0;
            residual = 0.0;
            good_count = 0;
            premature_converged = 0;
        end

        @(cross(V(decision_clk) - vth, +1)) begin
            if (V(rst) > vth || V(enable) <= vth) begin
                tap1_weight = 0.0;
                tap0_weight = 0.0;
                residual = 0.0;
                good_count = 0;
                premature_converged = 0;
            end else begin
                residual = (V(sample_in) - vcm) - tap1_weight * sign_from_voltage(V(hist_1)) - tap0_weight * sign_from_voltage(V(hist_0));

                if (sign_from_voltage(V(hist_1)) > 0.5) tap1_weight = tap1_weight + 0.04 * residual;
                else if (sign_from_voltage(V(hist_1)) < -0.5) tap1_weight = tap1_weight - 0.04 * residual;

                if (sign_from_voltage(V(hist_0)) > 0.5) tap0_weight = tap0_weight + 0.025 * residual;
                else if (sign_from_voltage(V(hist_0)) < -0.5) tap0_weight = tap0_weight - 0.025 * residual;

                if (tap1_weight > 0.18) tap1_weight = 0.18;
                else if (tap1_weight < -0.18) tap1_weight = -0.18;
                if (tap0_weight > 0.12) tap0_weight = 0.12;
                else if (tap0_weight < -0.12) tap0_weight = -0.12;

                residual = (V(sample_in) - vcm) - tap1_weight * sign_from_voltage(V(hist_1)) - tap0_weight * sign_from_voltage(V(hist_0));
                if (absval(residual) <= residual_tol) begin
                    if (good_count < 3) good_count = good_count + 1;
                    premature_converged = 1;
                end else begin
                    good_count = 0;
                end
            end
        end

        V(tap_1) <+ transition((V(rst) > vth || V(enable) <= vth) ? vcm : clamp_rail(vcm + tap1_weight), 0, tr, tr);
        V(tap_0) <+ transition((V(rst) > vth || V(enable) <= vth) ? vcm : clamp_rail(vcm + tap0_weight), 0, tr, tr);
        V(corrected_out) <+ transition((V(rst) > vth || V(enable) <= vth) ? vcm : clamp_rail(vcm + residual), 0, tr, tr);
        V(error_metric) <+ transition((V(rst) > vth || V(enable) <= vth) ? vss : clamp_rail(absval(residual)), 0, tr, tr);
        V(converged) <+ transition((V(rst) > vth || V(enable) <= vth) ? vss : (premature_converged ? vdd : vss), 0, tr, tr);
    end
endmodule
