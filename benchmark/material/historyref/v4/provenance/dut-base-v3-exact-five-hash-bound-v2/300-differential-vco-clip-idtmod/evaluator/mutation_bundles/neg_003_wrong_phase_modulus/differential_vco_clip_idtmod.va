// neg_003_wrong_phase_modulus: uses a 0.5 modulus instead of 1.0 so the phase
// wraps twice per cycle and both the sine output and the metric diverge from
// the reintegrated modulo-1 reference.
`include "constants.vams"
`include "disciplines.vams"

`define clip(x, LO, HI) ((x < LO) ? LO : (x > HI) ? HI : x)

module differential_vco_clip_idtmod (
    input  electrical vinp,
    input  electrical vinm,
    output electrical outp,
    output electrical outm,
    output electrical metric
);
    parameter real Fnom = 20.0e6 from (0:inf);
    parameter real dFdV = 160.0e6 exclude 0.0;
    parameter real Fmin = 5.0e6 from (0:inf);
    parameter real Fmax = 80.0e6 from (0:inf);
    parameter real Vcm = 0.45;
    parameter real Vac = 0.4 from (0:inf);

    real freq_q;
    real phase_q;

    analog begin
        freq_q = `clip(Fnom + dFdV * V(vinp, vinm), Fmin, Fmax);
        phase_q = idtmod(freq_q, 0.0, 0.5);
        V(outp) <+ Vcm + Vac * sin(`M_TWO_PI * phase_q);
        V(outm) <+ Vcm - Vac * sin(`M_TWO_PI * phase_q);
        V(metric) <+ 0.9 * phase_q;
    end
endmodule
