simulator lang=spectre
global 0

ahdl_include "./dut/clocked_adc3bit.va"

Vin (vin 0) vsource type=pwl wave=[0 0.05 0.8n 0.05 0.85n 0.30 1.6n 0.30 1.65n 0.62 2.4n 0.62 2.45n 0.99 3.2n 0.99]
Vclk (vclk 0) vsource type=pwl wave=[0 0 0.35n 0 0.37n 0.9 0.55n 0.9 0.57n 0 1.15n 0 1.17n 0.9 1.35n 0.9 1.37n 0 1.95n 0 1.97n 0.9 2.15n 0.9 2.17n 0 2.75n 0 2.77n 0.9 2.95n 0.9 2.97n 0 3.2n 0]
XDUT (vd2 vd1 vd0 vin vclk) clocked_adc3bit

simulatorOptions options evas_profile=balanced

tran tran stop=3.1n maxstep=5p
save vclk vd0 vd1 vd2 vin
