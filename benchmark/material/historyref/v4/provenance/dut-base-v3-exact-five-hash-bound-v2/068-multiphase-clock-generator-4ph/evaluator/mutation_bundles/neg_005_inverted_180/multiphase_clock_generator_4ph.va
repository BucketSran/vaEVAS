`include "constants.vams"
`include "disciplines.vams"

module multiphase_clock_generator_4ph(vss, clk0, clk90, clk180, clk270);
    input vss;
    output clk0, clk90, clk180, clk270;
    electrical vss, clk0, clk90, clk180, clk270;

    parameter real vdd = 0.9;
    parameter real vth = 0.45;
    parameter real tr = 20p;

    real p; real t0; real t90; real t180; real t270;
    analog begin
        p = 20n;
        t0 = $abstime - p*floor($abstime/p);
        t90 = ($abstime-5n) - p*floor(($abstime-5n)/p);
        t180 = ($abstime-10n) - p*floor(($abstime-10n)/p);
        t270 = ($abstime-15n) - p*floor(($abstime-15n)/p);
        V(clk0, vss) <+ transition((t0 < 10n) ? vdd : 0.0, 0, tr, tr);
        V(clk90, vss) <+ transition((t90 < 10n) ? vdd : 0.0, 0, tr, tr);
        V(clk180, vss) <+ transition((t180 < 10n) ? 0.0 : vdd, 0, tr, tr);
        V(clk270, vss) <+ transition((t270 < 10n) ? vdd : 0.0, 0, tr, tr);
    end
endmodule
