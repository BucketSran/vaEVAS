simulator lang=spectre
global 0

ahdl_include "./dut/bandgap_trim_top.va"
ahdl_include "./dut/startup_detector.va"
ahdl_include "./dut/ptat_ctat_core.va"
ahdl_include "./dut/trim_controller.va"

Vclk (clk 0) vsource type=pulse val0=0 val1=0.9 period=4.5n width=2.25n delay=0.9n rise=60p fall=60p
Vrst (rst 0) vsource type=pwl wave=[0 0.9 1.8n 0.9 1.9n 0 92n 0]
Vtrim (trim_req 0) vsource type=pwl wave=[0 0 7n 0 7.1n 0.9 61n 0.9 61.1n 0 69n 0 69.1n 0.9 92n 0.9]
Vvdd (vdd_sense 0) vsource type=pwl wave=[0 0 2.5n 0.52 5.5n 0.78 49n 0.86 60n 0.66 70n 0.83 92n 0.88]
Vtemp (temp_proxy 0) vsource type=pwl wave=[0 0.57 16n 0.57 31n 0.69 52n 0.49 73n 0.64 92n 0.59]

XDUT (vdd_sense clk rst trim_req temp_proxy vref trim_3 trim_2 trim_1 trim_0 ready error_metric) bandgap_trim_top

simulatorOptions options evas_profile=balanced

tran tran stop=92n maxstep=80p
save vdd_sense clk rst trim_req temp_proxy vref trim_3 trim_2 trim_1 trim_0 ready error_metric
