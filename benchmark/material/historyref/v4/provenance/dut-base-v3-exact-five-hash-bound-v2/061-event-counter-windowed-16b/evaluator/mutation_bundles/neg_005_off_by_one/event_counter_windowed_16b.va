`include "constants.vams"
`include "disciplines.vams"

module event_counter_windowed_16b(gate, event_in, done, count0, count1, count2, count3, count4, count5, count6, count7, count8, count9, count10, count11, count12, count13, count14, count15);
    input gate, event_in;
    output done, count0, count1, count2, count3, count4, count5, count6, count7, count8, count9, count10, count11, count12, count13, count14, count15;
    electrical gate, event_in, done, count0, count1, count2, count3, count4, count5, count6, count7, count8, count9, count10, count11, count12, count13, count14, count15;

    parameter real vdd = 0.9;
    parameter real vth = 0.45;
    parameter real tr = 20p;

    integer cnt; integer active; real done_level;
    analog begin
        @(initial_step) begin cnt=0; active=0; done_level=0; end
        @(cross(V(gate)-vth,+1)) begin cnt=1; active=1; done_level=0; end
        @(cross(V(event_in)-vth,+1)) begin if (active && V(gate)>vth) cnt=cnt+1; end
        @(cross(V(gate)-vth,-1)) begin active=0; done_level=vdd; end
        V(done) <+ transition(done_level, 0, tr, tr);
        V(count0) <+ transition((((cnt) >> 0) & 1) ? vdd : 0.0, 0, tr, tr);
        V(count1) <+ transition((((cnt) >> 1) & 1) ? vdd : 0.0, 0, tr, tr);
        V(count2) <+ transition((((cnt) >> 2) & 1) ? vdd : 0.0, 0, tr, tr);
        V(count3) <+ transition((((cnt) >> 3) & 1) ? vdd : 0.0, 0, tr, tr);
        V(count4) <+ transition((((cnt) >> 4) & 1) ? vdd : 0.0, 0, tr, tr);
        V(count5) <+ transition((((cnt) >> 5) & 1) ? vdd : 0.0, 0, tr, tr);
        V(count6) <+ transition((((cnt) >> 6) & 1) ? vdd : 0.0, 0, tr, tr);
        V(count7) <+ transition((((cnt) >> 7) & 1) ? vdd : 0.0, 0, tr, tr);
        V(count8) <+ transition((((cnt) >> 8) & 1) ? vdd : 0.0, 0, tr, tr);
        V(count9) <+ transition((((cnt) >> 9) & 1) ? vdd : 0.0, 0, tr, tr);
        V(count10) <+ transition((((cnt) >> 10) & 1) ? vdd : 0.0, 0, tr, tr);
        V(count11) <+ transition((((cnt) >> 11) & 1) ? vdd : 0.0, 0, tr, tr);
        V(count12) <+ transition((((cnt) >> 12) & 1) ? vdd : 0.0, 0, tr, tr);
        V(count13) <+ transition((((cnt) >> 13) & 1) ? vdd : 0.0, 0, tr, tr);
        V(count14) <+ transition((((cnt) >> 14) & 1) ? vdd : 0.0, 0, tr, tr);
        V(count15) <+ transition((((cnt) >> 15) & 1) ? vdd : 0.0, 0, tr, tr);
    end
endmodule
