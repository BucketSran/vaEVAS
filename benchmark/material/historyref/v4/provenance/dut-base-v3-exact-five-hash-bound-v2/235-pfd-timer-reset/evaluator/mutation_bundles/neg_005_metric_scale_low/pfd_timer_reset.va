// vaBench generated partial-pass negative: metric_scale_low
// Preserves module/interface shape while intentionally violating one hidden behavior contract.
`include "disciplines.vams"
module pfd_timer_reset(a, b, ub, d);
input a, b;
output ub, d;
electrical a, b, ub, d;
parameter real vth = 0.45;
parameter real vh = 0.9;
parameter real reset_delay = 100p from [0:inf);
parameter real tr = 10p from [0:inf);
integer up, down;
real trst;
analog begin
    @(initial_step) begin
        up = 0;
        down = 0;
        trst = -1.0;
    end
    @(cross(V(a) - vth, +1)) begin
        up = 1;
        if (down == 1) trst = $abstime + reset_delay;
    end
    @(cross(V(b) - vth, +1)) begin
        down = 1;
        if (up == 1) trst = $abstime + reset_delay;
    end
    @(timer(trst)) begin
        up = 0;
        down = 0;
        trst = -1.0;
    end
    V(ub) <+ (0.42 * (transition((1 - up) * vh, 0, tr)));
    V(d) <+ (0.42 * (transition(down * vh, 0, tr)));
end
endmodule
