simulator lang=spectre
global 0

ahdl_include "./dut/lc_vco_behavioral_source.va"

Ven (enable 0) vsource type=pwl wave=[0 0 10n 0 10.1n 0.9 820n 0.9 820.1n 0 870n 0 870.1n 0.9 1050n 0.9]
Vrst (rst 0) vsource type=pwl wave=[0 0.9 4n 0.9 4.1n 0 1050n 0]
Vctrl (vctrl 0) vsource type=pwl wave=[0 -0.1 250n -0.1 250.1n 0.45 600n 0.45 600.1n 1.0 1050n 1.0]
XDUT (vctrl enable rst osc_p osc_n freq_metric amp_metric valid) lc_vco_behavioral_source

simulatorOptions options evas_profile=balanced

tran tran stop=1050n maxstep=350p
save vctrl enable rst osc_p osc_n freq_metric amp_metric valid
