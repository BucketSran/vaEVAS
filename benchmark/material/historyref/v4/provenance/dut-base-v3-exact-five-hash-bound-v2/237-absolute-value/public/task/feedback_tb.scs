simulator lang=spectre
global 0

ahdl_include "./dut/absolute_value.va"

Vin (sigin 0) vsource type=pwl wave=[0 0.55 0.6n 0.55 0.65n -0.95 1.2n -0.95 1.25n -0.04 1.8n -0.04 1.85n 0.25 2.4n 0.25 2.45n 0.02 3.0n 0.02 3.05n -0.55 3.6n -0.55]
XDUT (sigin sigout) absolute_value

simulatorOptions options evas_profile=balanced

tran tran stop=3.4n maxstep=5p
save sigin sigout
