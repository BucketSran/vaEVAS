`include "disciplines.vams"
module decision_router_logic(vin1, vin2, valid, x, y, z, dm, dl);
input vin1, vin2, valid;
output x, y, z, dm, dl;
electrical vin1, vin2, valid, x, y, z, dm, dl;
parameter real vth = 0.45;
parameter real vh = 0.9;
integer a, b, ok;
analog begin
    a = V(vin1) > vth;
    b = V(vin2) > vth;
    ok = V(valid) > vth;
    V(dm) <+ ((!a && b) ? vh : 0.0);
    V(dl) <+ a ? vh : 0.0;
    V(x) <+ ((!a && !b && ok) ? vh : 0.0);
    V(y) <+ ((a && b && ok) ? vh : 0.0);
    V(z) <+ ((!a && b && ok) ? vh : 0.0);
end
endmodule
