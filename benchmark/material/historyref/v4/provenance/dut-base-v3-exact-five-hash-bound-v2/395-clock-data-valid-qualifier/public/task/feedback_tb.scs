simulator lang=spectre
global 0

ahdl_include "./dut/clock_data_valid_qualifier.va"

Vclk (clk 0) vsource type=pulse val0=0 val1=0.9 period=8n width=4n delay=1n rise=60p fall=60p
Vrst (rst 0) vsource type=pwl wave=[0 0.9 2n 0.9 2.1n 0 120n 0]
Ven (enable 0) vsource type=pwl wave=[0 0 3n 0 3.1n 0.9 94n 0.9 94.1n 0 102n 0 102.1n 0.9 120n 0.9]
Vdata (data 0) vsource type=pwl wave=[0 0 6n 0 6.1n 0.9 31n 0.9 31.1n 0 67n 0 67.1n 0.9 85n 0.9 85.1n 0 120n 0]
XDUT (clk data rst enable valid_out edge_age_metric qualified) clock_data_valid_qualifier max_age_cycles=3

simulatorOptions options evas_profile=balanced

tran tran stop=120n maxstep=80p
save clk data rst enable valid_out edge_age_metric qualified
