simulator lang=spectre
global 0

ahdl_include "./dut/sync_8b_dffs_v2.va"

Vck9 (ck9 0) vsource type=pwl wave=[0 0 1n 0 1.05n 0.9 1.45n 0.9 1.5n 0 11n 0 11.05n 0.9 11.45n 0.9 11.5n 0]
Vck8 (ck8 0) vsource type=pwl wave=[0 0 2n 0 2.05n 0.9 2.45n 0.9 2.5n 0 12n 0 12.05n 0.9 12.45n 0.9 12.5n 0]
Vck7 (ck7 0) vsource type=pwl wave=[0 0 3n 0 3.05n 0.9 3.45n 0.9 3.5n 0 13n 0 13.05n 0.9 13.45n 0.9 13.5n 0]
Vck6 (ck6 0) vsource type=pwl wave=[0 0 4n 0 4.05n 0.9 4.45n 0.9 4.5n 0 14n 0 14.05n 0.9 14.45n 0.9 14.5n 0]
Vck5 (ck5 0) vsource type=pwl wave=[0 0 5n 0 5.05n 0.9 5.45n 0.9 5.5n 0 15n 0 15.05n 0.9 15.45n 0.9 15.5n 0]
Vck4 (ck4 0) vsource type=pwl wave=[0 0 6n 0 6.05n 0.9 6.45n 0.9 6.5n 0 16n 0 16.05n 0.9 16.45n 0.9 16.5n 0]
Vck3 (ck3 0) vsource type=pwl wave=[0 0 7n 0 7.05n 0.9 7.45n 0.9 7.5n 0 17n 0 17.05n 0.9 17.45n 0.9 17.5n 0]
Vck2 (ck2 0) vsource type=pwl wave=[0 0 8n 0 8.05n 0.9 8.45n 0.9 8.5n 0 18n 0 18.05n 0.9 18.45n 0.9 18.5n 0]
Vck1 (ck1 0) vsource type=pwl wave=[0 0 9n 0 9.05n 0.9 9.45n 0.9 9.5n 0 19n 0 19.05n 0.9 19.45n 0.9 19.5n 0]
Vdl0 (dl0 0) vsource type=pwl wave=[0 0.9 9.25n 0.9 9.3n 0]
Vdl1 (dl1 0) vsource type=pwl wave=[0 0 8.25n 0 8.3n 0.9]
Vdl2 (dl2 0) vsource type=pwl wave=[0 0.9 7.25n 0.9 7.3n 0]
Vdl3 (dl3 0) vsource type=pwl wave=[0 0 6.25n 0 6.3n 0.9]
Vdl4 (dl4 0) vsource type=pwl wave=[0 0.9 5.25n 0.9 5.3n 0]
Vdl5 (dl5 0) vsource type=pwl wave=[0 0 4.25n 0 4.3n 0.9]
Vdl6 (dl6 0) vsource type=pwl wave=[0 0.9 3.25n 0.9 3.3n 0]
Vdl7 (dl7 0) vsource type=pwl wave=[0 0 2.25n 0 2.3n 0.9]
Vdl8 (dl8 0) vsource type=pwl wave=[0 0.9 1.25n 0.9 1.3n 0]
XDUT (ck1 ck2 ck3 ck4 ck5 ck6 ck7 ck8 ck9 dl0 dl1 dl2 dl3 dl4 dl5 dl6 dl7 dl8 do0 do1 do2 do3 do4 do5 do6 do7 do8) sync_8b_dffs_v2

simulatorOptions options evas_profile=balanced

tran tran stop=20.5n maxstep=20p
save ck1 ck2 ck3 ck4 ck5 ck6 ck7 ck8 ck9 dl0 dl1 dl2 dl3 dl4 dl5 dl6 dl7 dl8 do0 do1 do2 do3 do4 do5 do6 do7 do8
