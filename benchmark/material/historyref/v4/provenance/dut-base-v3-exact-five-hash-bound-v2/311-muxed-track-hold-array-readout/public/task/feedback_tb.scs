simulator lang=spectre
global 0

ahdl_include "./dut/muxed_track_hold_array_top.va"
ahdl_include "./dut/track_hold_cell.va"
ahdl_include "./dut/readout_mux.va"

Vvin0 (vin0 0) vsource type=pwl wave=[0 0.24 8n 0.24 14n 0.68 26n 0.68 34n 0.36 46n 0.36 66n 0.72 80n 0.72]
Vvin1 (vin1 0) vsource type=pwl wave=[0 0.44 8n 0.44 14n 0.30 26n 0.30 34n 0.74 46n 0.74 66n 0.28 80n 0.28]
Vvin2 (vin2 0) vsource type=pwl wave=[0 0.62 8n 0.62 14n 0.54 26n 0.54 34n 0.26 40n 0.26 43n 0.76 46n 0.76 66n 0.50 80n 0.50]
Vclk (clk 0) vsource type=pulse val0=0 val1=0.9 period=6n width=2.4n delay=3n rise=60p fall=60p
Vrst (rst 0) vsource type=pwl wave=[0 0.9 2.1n 0.9 2.2n 0 50n 0 50.1n 0.9 53.5n 0.9 53.6n 0 80n 0]
Vsel_1 (sel_1 0) vsource type=pwl wave=[0 0 10n 0 10.1n 0 22n 0 22.1n 0.9 33n 0.9 33.1n 0.9 49n 0.9 49.1n 0 60n 0 60.1n 0.9 80n 0.9]
Vsel_0 (sel_0 0) vsource type=pwl wave=[0 0 10n 0 10.1n 0.9 22n 0.9 22.1n 0 33n 0 33.1n 0 45n 0 45.1n 0 60n 0 60.1n 0.9 80n 0.9]
Vsample_en (sample_en 0) vsource type=pwl wave=[0 0 5n 0 5.1n 0.9 40n 0.9 40.1n 0 46n 0 46.1n 0.9 80n 0.9]
XDUT (vin0 vin1 vin2 clk rst sel_1 sel_0 sample_en vout channel_metric valid) muxed_track_hold_array_top

simulatorOptions options evas_profile=balanced

tran tran stop=80n maxstep=80p
save vin0 vin1 vin2 clk rst sel_1 sel_0 sample_en vout channel_metric valid
