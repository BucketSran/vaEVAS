simulator lang=spectre
global 0

ahdl_include "./dut/iq_upconversion_mixer.va"

Vi (i_in 0) vsource type=sine sinedc=0.45 ampl=0.16 freq=9Meg phase=20
Vq (q_in 0) vsource type=sine sinedc=0.45 ampl=0.11 freq=15Meg phase=70
Vloi (lo_i 0) vsource type=pulse val0=0 val1=0.9 delay=4n period=8n width=4n rise=25p fall=25p
Vloq (lo_q 0) vsource type=pulse val0=0 val1=0.9 delay=6n period=8n width=4n rise=25p fall=25p
Vrst (rst 0) vsource type=pwl wave=[0 0.9 1.2n 0.9 1.3n 0 91n 0 91.1n 0.9 97n 0.9 97.1n 0 125n 0]
Ven (enable 0) vsource type=pwl wave=[0 0 2n 0 2.1n 0.9 68n 0.9 68.1n 0 76n 0 76.1n 0.9 125n 0.9]
XDUT (i_in q_in lo_i lo_q rst enable rf_out i_mix_dbg q_mix_dbg quad_ok) iq_upconversion_mixer

simulatorOptions options evas_profile=balanced

tran tran stop=125n maxstep=50p
save i_in q_in lo_i lo_q rst enable rf_out i_mix_dbg q_mix_dbg quad_ok
