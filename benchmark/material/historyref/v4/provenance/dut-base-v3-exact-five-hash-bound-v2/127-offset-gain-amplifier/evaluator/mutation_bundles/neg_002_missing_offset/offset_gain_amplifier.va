`include "disciplines.vams"
module offset_gain_amplifier(sigin, sigout);
input sigin; output sigout; electrical sigin, sigout;
analog begin V(sigout) <+ 3.0*V(sigin); end
endmodule
