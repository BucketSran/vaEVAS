simulator lang=spectre
global 0

ahdl_include "./dut/quadrature_lo_generator_divided_clock.va"

Vclk (clk_in 0) vsource type=pulse val0=0 val1=0.9 period=5n width=2.5n delay=1.5n rise=50p fall=50p
Vrst (rst 0) vsource type=pwl wave=[0 0.9 2.5n 0.9 2.6n 0 108n 0]
Ven (enable 0) vsource type=pwl wave=[0 0 3.2n 0 3.3n 0.9 82n 0.9 82.1n 0 90n 0 90.1n 0.9 108n 0.9]
XDUT (clk_in rst enable lo_i lo_q div_metric quad_ok) quadrature_lo_generator_divided_clock

simulatorOptions options evas_profile=balanced

tran tran stop=108n maxstep=70p
save clk_in rst enable lo_i lo_q div_metric quad_ok
