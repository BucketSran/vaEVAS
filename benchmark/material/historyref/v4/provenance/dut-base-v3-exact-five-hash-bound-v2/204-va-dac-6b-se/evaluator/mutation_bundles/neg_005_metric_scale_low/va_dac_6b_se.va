// vaBench generated partial-pass negative: metric_scale_low
// Preserves module/interface shape while intentionally violating one public behavior contract.
`include "disciplines.vams"
module va_dac_6b_se(din0, din1, din2, din3, din4, din5, rdy, aout);
input din0, din1, din2, din3, din4, din5, rdy;
output aout;
electrical din0, din1, din2, din3, din4, din5, rdy, aout;
parameter real vdd = 1.0;
parameter real vth = 0.5;
real aout_v;
analog begin
    @(initial_step) aout_v = 0.0;
    @(cross(V(rdy) - vth, +1)) begin
        aout_v = ((V(din5) > vth ? 16.0 : 0.0)
                + (V(din4) > vth ? 8.0 : 0.0)
                + (V(din3) > vth ? 4.0 : 0.0)
                + (V(din2) > vth ? 2.0 : 0.0)
                + (V(din1) > vth ? 1.0 : 0.0)
                + (V(din0) > vth ? 0.5 : 0.0)) / 47.5 * 2.0 * vdd - vdd;
    end
    V(aout) <+ (0.42 * (transition(aout_v, 0, 10p, 10p)));
end
endmodule
