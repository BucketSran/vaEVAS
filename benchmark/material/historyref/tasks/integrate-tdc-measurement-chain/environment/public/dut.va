`include "rtl/capture.va"
`include "rtl/quantizer.va"
`include "rtl/formatter.va"
module tdc_chain(start,stop,reset,result,valid,busy,overflow);
input start,stop,reset; output result,valid,busy,overflow;
electrical start,stop,reset,result,valid,busy,overflow;
electrical width,done,pending,expired,code,range_error;
parameter real lsb_ns=0.5;
parameter real timeout_ns=12;
tdc_capture #(.timeout_ns(timeout_ns)) ucap(start,stop,reset,width,done,pending,expired);
tdc_quantizer #(.lsb_ns(lsb_ns)) uq(width,code,range_error);
// TODO integrate status and calibrated result formatting.
analog begin V(result)<+V(width); V(valid)<+V(done); V(busy)<+0; V(overflow)<+0; end
endmodule
