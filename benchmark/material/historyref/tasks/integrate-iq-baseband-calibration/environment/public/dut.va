`include "rtl/coeff.va"
`include "rtl/inverse.va"
`include "rtl/sample.va"
module iq_calibration(ri,rq,a,b,c,d,oi,oq,apply,clk,bypass,reset,out_i,out_q,clipped);
input ri,rq,a,b,c,d,oi,oq,apply,clk,bypass,reset; output out_i,out_q,clipped;
electrical ri,rq,a,b,c,d,oi,oq,apply,clk,bypass,reset,out_i,out_q,clipped;
electrical la,lb,lc,ld,li,lq,ci,cq;
iq_coeff uc(a,b,c,d,oi,oq,apply,reset,la,lb,lc,ld,li,lq);
// TODO insert calibrated matrix inverse in the receive path.
analog begin V(ci)<+V(ri); V(cq)<+V(rq); end
iq_sample us(ri,rq,ci,cq,clk,bypass,reset,out_i,out_q,clipped);
endmodule
