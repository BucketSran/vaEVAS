`include "constants.vams"
`include "disciplines.vams"
module dut(p1,p2);
inout p1,p2;electrical p1,p2;
parameter real period=100n,dead=5n;
integer a,b;
analog begin
 @(initial_step)begin a=0;b=0;end
 @(timer(dead,period))a=1;
 @(timer(period/2,period))a=0;
 @(timer(period/2+dead,period))b=1;
 @(timer(period,period))b=0;
 V(p1)<+0.49+0.02*transition(a,0,0.1n);V(p2)<+0.49+0.02*transition(b,0,0.1n);
end
endmodule
