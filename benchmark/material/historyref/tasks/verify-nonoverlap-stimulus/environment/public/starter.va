`include "constants.vams"
`include "disciplines.vams"
module dut(p1,p2);
inout p1,p2; electrical p1,p2;
// TODO: implement the required experiment and result ports.
endmodule
