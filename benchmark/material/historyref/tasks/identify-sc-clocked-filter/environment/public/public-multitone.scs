simulator lang=spectre
global 0
ahdl_include "dut.va"
Vvin (vin 0) vsource type=pwl wave=[0 0.501045662488 4.5e-06 0.501045662488 4.502e-06 0.606224068857 7.5e-06 0.606224068857 7.502e-06 0.515213724713 1.05e-05 0.515213724713 1.0502e-05 0.253004765707 1.35e-05 0.253004765707 1.3502e-05 -0.0804892925033 1.65e-05 -0.0804892925033 1.6502e-05 -0.355492934951 1.95e-05 -0.355492934951 1.9502e-05 -0.471143722839 2.25e-05 -0.471143722839 2.2502e-05 -0.400624051528 2.55e-05 -0.400624051528 2.5502e-05 -0.201684935583 2.85e-05 -0.201684935583 2.8502e-05 0.0122122293863 3.15e-05 0.0122122293863 3.1502e-05 0.126496677705 3.45e-05 0.126496677705 3.4502e-05 0.0801715615065 3.75e-05 0.0801715615065 3.7502e-05 -0.105087082494 4.05e-05 -0.105087082494 4.0502e-05 -0.33507279148 4.35e-05 -0.33507279148 4.3502e-05 -0.487686791226 4.65e-05 -0.487686791226 4.6502e-05 -0.471143722839 4.95e-05 -0.471143722839 4.9502e-05 -0.268430195253 5.25e-05 -0.268430195253 5.2502e-05 0.0528985633937 5.55e-05 0.0528985633937 5.5502e-05 0.370304077588 5.85e-05 0.370304077588 5.8502e-05 0.561538840912 6.15e-05 0.561538840912 6.1502e-05 0.559898952658 6.45e-05 0.559898952658 6.4502e-05 0.383746350607 6.75e-05 0.383746350607 6.7502e-05 0.126612144103 7.05e-05 0.126612144103 7.0502e-05 -0.0873914127655 7.35e-05 -0.0873914127655 7.3502e-05 -0.161925978493 7.65e-05 -0.161925978493 7.6502e-05 -0.0732233505409 7.95e-05 -0.0732233505409 7.9502e-05 0.11961690981 8.25e-05 0.11961690981 8.2502e-05 0.303585731171 8.55e-05 0.303585731171 8.5502e-05 0.3663319962 8.85e-05 0.3663319962 8.8502e-05 0.250681208311 9.15e-05 0.250681208311 9.1502e-05 -0.0165490278529 9.45e-05 -0.0165490278529 9.4502e-05 -0.33507279148 9.75e-05 -0.33507279148 9.7502e-05 -0.576224845867 0.0001005 -0.576224845867 0.000100502 -0.641653369644 0.0001035 -0.641653369644 0.000103502 -0.508265513747 0.0001065 -0.508265513747 0.000106502 -0.238474938391 0.0001095 -0.238474938391 0.000109502 0.0490022321946 0.0001125 0.0490022321946 0.000112502 0.234138139925 0.0001155 0.234138139925 0.000115502 0.250681208311 0.0001185 0.250681208311 0.000118502 0.115644828422 0.0001215 0.115644828422 0.000121502 -0.0804892925033 0.0001245 -0.0804892925033 0.000124502 -0.218132997666 0.0001275 -0.218132997666 0.000127502 -0.206611206438 0.0001305 -0.206611206438 0.000130502 -0.0285381225957 0.0001335 -0.0285381225957 0.000133502 0.25035849471 0.0001365 0.25035849471 0.000136502 0.510687167778 0.0001395 0.510687167778 0.000139502 0.634433518385 0.0001425 0.634433518385 0.000142502 0.559898952658 0.0001455 0.559898952658 0.000145502 0.310851673134 0.0001485 0.310851673134 0.000148502 -0.0137709460869 0.0001515 -0.0137709460869 0.000151502 -0.284851344082 0.0001545 -0.284851344082 0.000154502 -0.40181805115 0.0001575 -0.40181805115 0.000157502 -0.337755866942 0.0001605 -0.337755866942 0.000160502 -0.14993688375 0.0001635 -0.14993688375 0.000163502 0.0490022321946 0.0001665 0.0490022321946 0.000166502 0.145600085283 0.0001695 0.145600085283 0.000169502 0.0801715615065 0.0001725 0.0801715615065 0.000172502 -0.124190490072 0.0001755 -0.124190490072 0.000175502 -0.371862794288 0.0001785 -0.371862794288 0.000178502 -0.539434843059 0.0001815 -0.539434843059 0.000181502 -0.534011907425 0.0001845 -0.534011907425 0.000184502 -0.337755866942 0.0001875 -0.337755866942 0.000187502 -0.0177430274748 0.0001905 -0.0177430274748 0.000190502 0.303585731171 0.0001935 0.303585731171 0.000193502 0.503691933485 0.0001965 0.503691933485 0.000196502 0.515213724713 0.0001995 0.515213724713 0.000199502 0.355536901079 0.0002025 0.355536901079 0.000202502 0.116970638813 0.0002055 0.116970638813 0.000205502 -0.0777499074759 0.0002085 -0.0777499074759 0.000208502 -0.133716528964 0.0002115 -0.133716528964 0.000211502 -0.0285381225957 0.0002145 -0.0285381225957 0.000214502 0.177463817237 0.0002175 0.177463817237 0.000217502 0.370304077588 0.0002205 0.370304077588 0.000220502 0.436973587068 0.0002235 0.436973587068 0.000223502 0.320006880001 0.0002265 0.320006880001 0.000226502 0.0463191567326 0.0002295 0.0463191567326 0.000229502 -0.283324739647 0.0002325 -0.283324739647 0.000232502 -0.539434843059 0.0002355 -0.539434843059 0.000235502 -0.622549962066 0.0002385 -0.622549962066 0.000238502 -0.508265513747 0.0002415 -0.508265513747 0.000241502 -0.257578345969 0.0002445 -0.257578345969 0.000244502 0.0122122293863 0.0002475 0.0122122293863 0.000247502 0.182390088092 0.0002505 0.182390088092 0.000250502 0.187813023726 0.0002535 0.187813023726 0.000253502 0.0463191567326 0.0002565 0.0463191567326 0.000256502 -0.151130883372 0.0002595 -0.151130883372 0.000259502 -0.284851344082 0.0002625 -0.284851344082 0.000262502 -0.264458113865 0.0002655 -0.264458113865 0.000265502 -0.0732233505409 0.0002685 -0.0732233505409 0.000268502 0.222149045182 0.0002715 0.222149045182 0.000271502 0.501045662488 0.0002745 0.501045662488 0.000274502 0.644075023675 0.0002775 0.644075023675 0.000277502 0.588108402186 0.0002805 0.588108402186 0.000280502 0.355536901079 0.0002835 0.355536901079 0.000283502 0.0440759613398 0.0002865 0.0440759613398 0.000286502 -0.218132997666 0.000291 -0.218132997666]
Vclk (clk 0) vsource type=pwl wave=[0 0 3e-06 0 3.002e-06 1 4.5e-06 1 4.502e-06 0 6e-06 0 6.002e-06 1 7.5e-06 1 7.502e-06 0 9e-06 0 9.002e-06 1 1.05e-05 1 1.0502e-05 0 1.2e-05 0 1.2002e-05 1 1.35e-05 1 1.3502e-05 0 1.5e-05 0 1.5002e-05 1 1.65e-05 1 1.6502e-05 0 1.8e-05 0 1.8002e-05 1 1.95e-05 1 1.9502e-05 0 2.1e-05 0 2.1002e-05 1 2.25e-05 1 2.2502e-05 0 2.4e-05 0 2.4002e-05 1 2.55e-05 1 2.5502e-05 0 2.7e-05 0 2.7002e-05 1 2.85e-05 1 2.8502e-05 0 3e-05 0 3.0002e-05 1 3.15e-05 1 3.1502e-05 0 3.3e-05 0 3.3002e-05 1 3.45e-05 1 3.4502e-05 0 3.6e-05 0 3.6002e-05 1 3.75e-05 1 3.7502e-05 0 3.9e-05 0 3.9002e-05 1 4.05e-05 1 4.0502e-05 0 4.2e-05 0 4.2002e-05 1 4.35e-05 1 4.3502e-05 0 4.5e-05 0 4.5002e-05 1 4.65e-05 1 4.6502e-05 0 4.8e-05 0 4.8002e-05 1 4.95e-05 1 4.9502e-05 0 5.1e-05 0 5.1002e-05 1 5.25e-05 1 5.2502e-05 0 5.4e-05 0 5.4002e-05 1 5.55e-05 1 5.5502e-05 0 5.7e-05 0 5.7002e-05 1 5.85e-05 1 5.8502e-05 0 6e-05 0 6.0002e-05 1 6.15e-05 1 6.1502e-05 0 6.3e-05 0 6.3002e-05 1 6.45e-05 1 6.4502e-05 0 6.6e-05 0 6.6002e-05 1 6.75e-05 1 6.7502e-05 0 6.9e-05 0 6.9002e-05 1 7.05e-05 1 7.0502e-05 0 7.2e-05 0 7.2002e-05 1 7.35e-05 1 7.3502e-05 0 7.5e-05 0 7.5002e-05 1 7.65e-05 1 7.6502e-05 0 7.8e-05 0 7.8002e-05 1 7.95e-05 1 7.9502e-05 0 8.1e-05 0 8.1002e-05 1 8.25e-05 1 8.2502e-05 0 8.4e-05 0 8.4002e-05 1 8.55e-05 1 8.5502e-05 0 8.7e-05 0 8.7002e-05 1 8.85e-05 1 8.8502e-05 0 9e-05 0 9.0002e-05 1 9.15e-05 1 9.1502e-05 0 9.3e-05 0 9.3002e-05 1 9.45e-05 1 9.4502e-05 0 9.6e-05 0 9.6002e-05 1 9.75e-05 1 9.7502e-05 0 9.9e-05 0 9.9002e-05 1 0.0001005 1 0.000100502 0 0.000102 0 0.000102002 1 0.0001035 1 0.000103502 0 0.000105 0 0.000105002 1 0.0001065 1 0.000106502 0 0.000108 0 0.000108002 1 0.0001095 1 0.000109502 0 0.000111 0 0.000111002 1 0.0001125 1 0.000112502 0 0.000114 0 0.000114002 1 0.0001155 1 0.000115502 0 0.000117 0 0.000117002 1 0.0001185 1 0.000118502 0 0.00012 0 0.000120002 1 0.0001215 1 0.000121502 0 0.000123 0 0.000123002 1 0.0001245 1 0.000124502 0 0.000126 0 0.000126002 1 0.0001275 1 0.000127502 0 0.000129 0 0.000129002 1 0.0001305 1 0.000130502 0 0.000132 0 0.000132002 1 0.0001335 1 0.000133502 0 0.000135 0 0.000135002 1 0.0001365 1 0.000136502 0 0.000138 0 0.000138002 1 0.0001395 1 0.000139502 0 0.000141 0 0.000141002 1 0.0001425 1 0.000142502 0 0.000144 0 0.000144002 1 0.0001455 1 0.000145502 0 0.000147 0 0.000147002 1 0.0001485 1 0.000148502 0 0.00015 0 0.000150002 1 0.0001515 1 0.000151502 0 0.000153 0 0.000153002 1 0.0001545 1 0.000154502 0 0.000156 0 0.000156002 1 0.0001575 1 0.000157502 0 0.000159 0 0.000159002 1 0.0001605 1 0.000160502 0 0.000162 0 0.000162002 1 0.0001635 1 0.000163502 0 0.000165 0 0.000165002 1 0.0001665 1 0.000166502 0 0.000168 0 0.000168002 1 0.0001695 1 0.000169502 0 0.000171 0 0.000171002 1 0.0001725 1 0.000172502 0 0.000174 0 0.000174002 1 0.0001755 1 0.000175502 0 0.000177 0 0.000177002 1 0.0001785 1 0.000178502 0 0.00018 0 0.000180002 1 0.0001815 1 0.000181502 0 0.000183 0 0.000183002 1 0.0001845 1 0.000184502 0 0.000186 0 0.000186002 1 0.0001875 1 0.000187502 0 0.000189 0 0.000189002 1 0.0001905 1 0.000190502 0 0.000192 0 0.000192002 1 0.0001935 1 0.000193502 0 0.000195 0 0.000195002 1 0.0001965 1 0.000196502 0 0.000198 0 0.000198002 1 0.0001995 1 0.000199502 0 0.000201 0 0.000201002 1 0.0002025 1 0.000202502 0 0.000204 0 0.000204002 1 0.0002055 1 0.000205502 0 0.000207 0 0.000207002 1 0.0002085 1 0.000208502 0 0.00021 0 0.000210002 1 0.0002115 1 0.000211502 0 0.000213 0 0.000213002 1 0.0002145 1 0.000214502 0 0.000216 0 0.000216002 1 0.0002175 1 0.000217502 0 0.000219 0 0.000219002 1 0.0002205 1 0.000220502 0 0.000222 0 0.000222002 1 0.0002235 1 0.000223502 0 0.000225 0 0.000225002 1 0.0002265 1 0.000226502 0 0.000228 0 0.000228002 1 0.0002295 1 0.000229502 0 0.000231 0 0.000231002 1 0.0002325 1 0.000232502 0 0.000234 0 0.000234002 1 0.0002355 1 0.000235502 0 0.000237 0 0.000237002 1 0.0002385 1 0.000238502 0 0.00024 0 0.000240002 1 0.0002415 1 0.000241502 0 0.000243 0 0.000243002 1 0.0002445 1 0.000244502 0 0.000246 0 0.000246002 1 0.0002475 1 0.000247502 0 0.000249 0 0.000249002 1 0.0002505 1 0.000250502 0 0.000252 0 0.000252002 1 0.0002535 1 0.000253502 0 0.000255 0 0.000255002 1 0.0002565 1 0.000256502 0 0.000258 0 0.000258002 1 0.0002595 1 0.000259502 0 0.000261 0 0.000261002 1 0.0002625 1 0.000262502 0 0.000264 0 0.000264002 1 0.0002655 1 0.000265502 0 0.000267 0 0.000267002 1 0.0002685 1 0.000268502 0 0.00027 0 0.000270002 1 0.0002715 1 0.000271502 0 0.000273 0 0.000273002 1 0.0002745 1 0.000274502 0 0.000276 0 0.000276002 1 0.0002775 1 0.000277502 0 0.000279 0 0.000279002 1 0.0002805 1 0.000280502 0 0.000282 0 0.000282002 1 0.0002835 1 0.000283502 0 0.000285 0 0.000285002 1 0.0002865 1 0.000286502 0 0.000288 0 0.000288002 1 0.0002895 1 0.000289502 0 0.000291 0]
DUT (vin clk out) identified_sc
simulatorOptions options reltol=1e-7 vabstol=1e-10 iabstol=1e-13
tran tran stop=0.000291 maxstep=2.5e-07 errpreset=conservative
save out vin clk
