simulator lang=spectre
global 0
ahdl_include "dut.va"
A (0 a_simple a_reverse a_extend a_mirror a_qs a_qr a_qe a_qm) transition_default edge=0.5 delay=0
B (0 b_simple b_reverse b_extend b_mirror b_qs b_qr b_qe b_qm) transition_default edge=1 delay=0.125
simulatorOptions options reltol=1e-9 vabstol=1e-11 iabstol=1e-15 precision="%24.17g"
tran tran stop=3 maxstep=0.015625 errpreset=conservative method=traponly strobeoutput=all strobetimes=[0 0.0078125 0.015625 0.0234375 0.03125 0.0390625 0.046875 0.0546875 0.0625 0.0703125 0.078125 0.0859375 0.09375 0.1015625 0.109375 0.1171875 0.125 0.1328125 0.140625 0.1484375 0.15625 0.1640625 0.171875 0.1796875 0.1875 0.1953125 0.203125 0.2109375 0.21875 0.2265625 0.234375 0.2421875 0.24999999999999997 0.25 0.25000000000000006 0.2578125 0.265625 0.2734375 0.28125 0.2890625 0.296875 0.3046875 0.3125 0.3203125 0.328125 0.3359375 0.34375 0.3515625 0.359375 0.3671875 0.37499999999999994 0.375 0.37500000000000006 0.3828125 0.390625 0.3984375 0.40625 0.4140625 0.421875 0.4296875 0.4375 0.4453125 0.453125 0.4609375 0.46875 0.4765625 0.484375 0.4921875 0.49999999999999994 0.5 0.50000000000000011 0.5078125 0.515625 0.5234375 0.53125 0.5390625 0.546875 0.5546875 0.5625 0.5703125 0.578125 0.5859375 0.59375 0.6015625 0.609375 0.6171875 0.62499999999999989 0.625 0.62500000000000011 0.6328125 0.640625 0.6484375 0.65625 0.6640625 0.671875 0.6796875 0.6875 0.6953125 0.703125 0.7109375 0.71875 0.7265625 0.734375 0.7421875 0.74999999999999989 0.75 0.75000000000000011 0.7578125 0.765625 0.7734375 0.78125 0.7890625 0.796875 0.8046875 0.8125 0.8203125 0.828125 0.8359375 0.84375 0.8515625 0.859375 0.8671875 0.87499999999999989 0.875 0.87500000000000011 0.8828125 0.890625 0.8984375 0.90625 0.9140625 0.921875 0.9296875 0.9375 0.9453125 0.953125 0.9609375 0.96875 0.9765625 0.984375 0.9921875 1 1.0078125 1.015625 1.0234375 1.03125 1.0390625 1.046875 1.0546875 1.0625 1.0703125 1.078125 1.0859375 1.09375 1.1015625 1.109375 1.1171875 1.125 1.1328125 1.140625 1.1484375 1.15625 1.1640625 1.171875 1.1796875 1.1875 1.1953125 1.203125 1.2109375 1.21875 1.2265625 1.234375 1.2421875 1.25 1.2578125 1.265625 1.2734375 1.28125 1.2890625 1.296875 1.3046875 1.3125 1.3203125 1.328125 1.3359375 1.34375 1.3515625 1.359375 1.3671875 1.3749999999999998 1.375 1.3750000000000002 1.3828125 1.390625 1.3984375 1.40625 1.4140625 1.421875 1.4296875 1.4375 1.4453125 1.453125 1.4609375 1.46875 1.4765625 1.484375 1.4921875 1.4999999999999998 1.5 1.5000000000000002 1.5078125 1.515625 1.5234375 1.53125 1.5390625 1.546875 1.5546875 1.5625 1.5703125 1.578125 1.5859375 1.59375 1.6015625 1.609375 1.6171875 1.6249999999999998 1.625 1.6250000000000002 1.6328125 1.640625 1.6484375 1.65625 1.6640625 1.671875 1.6796875 1.6875 1.6953125 1.703125 1.7109375 1.71875 1.7265625 1.734375 1.7421875 1.75 1.7578125 1.765625 1.7734375 1.78125 1.7890625 1.796875 1.8046875 1.8125 1.8203125 1.828125 1.8359375 1.84375 1.8515625 1.859375 1.8671875 1.875 1.8828125 1.890625 1.8984375 1.90625 1.9140625 1.921875 1.9296875 1.9375 1.9453125 1.953125 1.9609375 1.96875 1.9765625 1.984375 1.9921875 1.9999999999999998 2 2.0000000000000004 2.0078125 2.015625 2.0234375 2.03125 2.0390625 2.046875 2.0546875 2.0625 2.0703125 2.078125 2.0859375 2.09375 2.1015625 2.109375 2.1171875 2.125 2.1328125 2.140625 2.1484375 2.15625 2.1640625 2.171875 2.1796875 2.1875 2.1953125 2.203125 2.2109375 2.21875 2.2265625 2.234375 2.2421875 2.25 2.2578125 2.265625 2.2734375 2.28125 2.2890625 2.296875 2.3046875 2.3125 2.3203125 2.328125 2.3359375 2.34375 2.3515625 2.359375 2.3671875 2.375 2.3828125 2.390625 2.3984375 2.40625 2.4140625 2.421875 2.4296875 2.4375 2.4453125 2.453125 2.4609375 2.46875 2.4765625 2.484375 2.4921875 2.5 2.5078125 2.515625 2.5234375 2.53125 2.5390625 2.546875 2.5546875 2.5625 2.5703125 2.578125 2.5859375 2.59375 2.6015625 2.609375 2.6171875 2.6249999999999996 2.625 2.6250000000000004 2.6328125 2.640625 2.6484375 2.65625 2.6640625 2.671875 2.6796875 2.6875 2.6953125 2.703125 2.7109375 2.71875 2.7265625 2.734375 2.7421875 2.75 2.7578125 2.765625 2.7734375 2.78125 2.7890625 2.796875 2.8046875 2.8125 2.8203125 2.828125 2.8359375 2.84375 2.8515625 2.859375 2.8671875 2.875 2.8828125 2.890625 2.8984375 2.90625 2.9140625 2.921875 2.9296875 2.9375 2.9453125 2.953125 2.9609375 2.96875 2.9765625 2.984375 2.9921875 3]
save a_simple a_reverse a_extend a_mirror a_qs a_qr a_qe a_qm b_simple b_reverse b_extend b_mirror b_qs b_qr b_qe b_qm
