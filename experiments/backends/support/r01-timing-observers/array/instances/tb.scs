simulator lang=spectre
ahdl_include "dut.va"
simulatorOptions options reltol=1e-6 vabstol=1e-9
Vu (u 0) vsource dc=0
X_one (u y1 0) m k=3
X_two (u y2 0) m k=5
tran tran stop=1 maxstep=0.125 strobeperiod=0.25
save y1 y2
