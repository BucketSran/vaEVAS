`include "disciplines.vams"
module m(u,y,r); input u;output y;inout r;electrical u,y,r;integer b;real a[0:1]; analog begin @(timer(0.5)) a[b]=7; V(y,r)<+a[0]; end endmodule
