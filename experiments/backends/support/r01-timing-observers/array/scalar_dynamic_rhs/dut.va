`include "disciplines.vams"
module m(u,y,r); input u;output y;inout r;electrical u,y,r;integer b;real a[0:1],x; analog begin @(initial_step) begin b=1;a[1]=7;end @(timer(0.5)) x=a[b]; V(y,r)<+x; end endmodule
