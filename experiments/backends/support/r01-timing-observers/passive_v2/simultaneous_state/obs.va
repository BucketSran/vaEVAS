`include "disciplines.vams"
module obs(u,y); input u,y; electrical u,y; real seen,due; integer count; analog begin @(initial_step) begin seen=0;due=100;count=0;end @(cross(V(u)-0.5,1,0.001,0.001)) begin if(V(y)>0.4) begin seen=V(y); due=0.75; $display("seen %.12g",seen); end end @(timer(due)) begin count=count+1;$display("due %d",count); end @(final_step) $display("final %.12g %d",seen,count); end endmodule
