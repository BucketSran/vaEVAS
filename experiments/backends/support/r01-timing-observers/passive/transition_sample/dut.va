`include "disciplines.vams"
module dut(u,y); input u; output y; electrical u,y; real q; analog begin @(initial_step) q=0; @(timer(0.5)) q=1; V(y)<+transition(q,0.0,0.5,0.5); end endmodule
