`include "disciplines.vams"
module m(u,y,r); input u; output y; inout r; electrical u,y,r; real x;
analog begin @(timer(0.5)) if((V(u,r)>0.0 ? V(y,r):0.0)>0.0) x=1; V(y,r)<+1; end
endmodule
