`include "disciplines.vams"
module m(u,y,r); input u; output y; inout r; electrical u,y,r; genvar i; real n;
analog begin @(timer(0.5)) for(i=0;i<1;i=i+1) begin if(abs(V(u,r))>0.5) n=n+1; if(min(V(u,r),0)<-0.5) n=n+10; if(max(V(u,r),0)<0.5) n=n+100; end V(y,r)<+n; end
endmodule
