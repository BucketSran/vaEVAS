`include "disciplines.vams"
module m(u,y,r); input u; output y; inout r; electrical u,y,r; integer x;
analog begin @(timer(0.5)) x=(V(u,r)>0.0)+1; V(y,r)<+x; end
endmodule
