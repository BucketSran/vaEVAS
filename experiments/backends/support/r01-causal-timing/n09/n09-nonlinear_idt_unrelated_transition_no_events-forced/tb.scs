simulator lang=spectre
ahdl_include "dut.va"
Vu (u 0) vsource type=pwl wave=[0 0 0.5 0.5]
Vs (s 0) vsource type=pwl wave=[0 0 0.5 0.5]
dut (u s x a y g) m
simulatorOptions options precision="%.17g" reltol=1e-9 vabstol=1e-12 iabstol=1e-15
tran tran stop=0.5 maxstep=0.002 method=traponly errpreset=conservative compression=no strobeoutput=all strobetimes=[0 0.125 0.25 0.28125 0.3125 0.34375 0.375 0.5]
save u s x a y g
