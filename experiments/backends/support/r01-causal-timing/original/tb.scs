simulator lang=spectre
global 0
simulatorOptions options reltol=1e-6 vabstol=1e-9 iabstol=1e-15
ahdl_include "core.va"
ahdl_include "circuit.va"
ahdl_include "dut.va"
V_vin (vin 0) vsource type=pwl wave=[0 0.3 7.5e-08 0.3 7.52e-08 1.6 1.55e-07 1.6 1.552e-07 0.2 3.3e-07 0.2 3.302e-07 1.1 4.7e-07 1.1 4.702e-07 0.55 7.9e-07 0.55 7.902e-07 1.45]
V_rst (rst 0) vsource type=pwl wave=[0 0 3.5e-07 0 3.502e-07 1.8 3.64e-07 1.8 3.642e-07 0 6.2e-07 0 6.202e-07 1.8 6.34e-07 1.8 6.342e-07 0]
V_track0 (track0 0) vsource type=pwl wave=[0 0 3e-08 0 3.02e-08 1.8 6e-08 1.8 6.02e-08 0 1.5e-07 0 1.502e-07 1.8 1.85e-07 1.8 1.852e-07 0 3e-07 0 3.002e-07 1.8 3.6e-07 1.8 3.602e-07 0 4.8e-07 0 4.802e-07 1.8 5.1e-07 1.8 5.102e-07 0 7.2e-07 0 7.202e-07 1.8 7.65e-07 1.8 7.652e-07 0]
V_track1 (track1 0) vsource type=pwl wave=[0 0 8e-08 0 8.02e-08 1.8 1.1e-07 1.8 1.102e-07 0 2.3e-07 0 2.302e-07 1.8 2.55e-07 1.8 2.552e-07 0 3.65e-07 0 3.652e-07 1.8 4.05e-07 1.8 4.052e-07 0 5.6e-07 0 5.602e-07 1.8 6.1e-07 1.8 6.102e-07 0 8e-07 0 8.002e-07 1.8 8.55e-07 1.8 8.552e-07 0]
V_read_clk (read_clk 0) vsource type=pwl wave=[0 0 7e-08 0 7.02e-08 1.8 7.5e-08 1.8 7.52e-08 0 1.2e-07 0 1.202e-07 1.8 1.25e-07 1.8 1.252e-07 0 1.35e-07 0 1.352e-07 1.8 1.4e-07 1.8 1.402e-07 0 2e-07 0 2.002e-07 1.8 2.05e-07 1.8 2.052e-07 0 2.7e-07 0 2.702e-07 1.8 2.75e-07 1.8 2.752e-07 0 3.2e-07 0 3.202e-07 1.8 3.25e-07 1.8 3.252e-07 0 4.3e-07 0 4.302e-07 1.8 4.35e-07 1.8 4.352e-07 0 5.3e-07 0 5.302e-07 1.8 5.35e-07 1.8 5.352e-07 0 6.4e-07 0 6.402e-07 1.8 6.45e-07 1.8 6.452e-07 0 7.8e-07 0 7.802e-07 1.8 7.85e-07 1.8 7.852e-07 0 8.75e-07 0 8.752e-07 1.8 8.8e-07 1.8 8.802e-07 0]
X_DUT (vin track0 track1 read_clk rst held0 held1 serial valid branch_id sample_index sample_time) r01_interleaved_sampler vinit=0.8 tau_hold=2e-06 vleak=0.1 pedestal=0.006 vcm=0.9 time_scale=1e-06 gain0=0.98 gain1=1.03 offset0=-0.015 offset1=0.02 tau_acq0=1e-08 tau_acq1=1.3e-08
X_M (vin track0 track1 read_clk rst held0 held1 serial valid branch_id sample_index sample_time) interleaved_measure observe_delay=5e-09 vcm=0.9 vinit=0.8 acq_nominal=3e-08 wait_nominal=8e-09 time_scale=1e-06
tran tran stop=9e-07 maxstep=100p errpreset=conservative
save vin rst track0 track1 read_clk held0 held1 serial valid branch_id sample_index sample_time
