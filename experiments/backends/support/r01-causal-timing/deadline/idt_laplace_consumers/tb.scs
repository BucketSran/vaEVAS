simulator lang=spectre
ahdl_include "dut.va"
Vu (u 0) vsource type=pwl wave=[0 0 1 3]
dut (u y 0) m
simulatorOptions options precision="%.17g" reltol=1e-9 vabstol=1e-12 iabstol=1e-15
tran tran stop=0.5 maxstep=1e-5 method=traponly errpreset=conservative compression=no strobeoutput=all strobetimes=[0 0.29999999999999999 0.34000000000000002 0.34999999999999998 0.5]
save u y dut.a dut.i dut.f
