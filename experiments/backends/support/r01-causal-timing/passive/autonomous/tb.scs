simulator lang=spectre
ahdl_include "dut.va"
Vu (u 0) vsource type=pwl wave=[0 0 1 3]
D (u z e) physical
M (u z) observer
simulatorOptions options precision="%.17g" reltol=1e-9 vabstol=1e-12 iabstol=1e-15 saveahdlvars=all
tran tran stop=0.75 maxstep=1e-5 method=traponly errpreset=conservative compression=no strobeoutput=strobeonly strobetimes=[0 0.29999999999999999 0.43333333333333329 0.43333333333333335 0.4333333333333334 0.59999999999999998 0.75]
save u z e M:due M:seen M:count
