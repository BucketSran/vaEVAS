simulator lang=spectre
ahdl_include "dut.va"
D (z) physical
M (z) observer
simulatorOptions options precision="%.17g" reltol=1e-10 vabstol=1e-13 iabstol=1e-15 saveahdlvars=all
tran tran stop=2 maxstep=1e-6 method=traponly errpreset=conservative compression=no strobeoutput=strobeonly strobetimes=[0 0.25 0.5 1 2]
save z D:q
