`include "disciplines.vams"
module singular(y,edge,count);
inout y,edge,count; electrical y,edge,count;
parameter real T=9.5367431640625e-7; parameter real TT=1e-12;
integer q,n; real e;
analog begin
@(initial_step) begin q=0; n=0; end
@(timer(T,0,TT)) begin q=1; n=n+1; end
e=transition(q,0,T,T);
V(edge)<+e;
V(y)<+e*V(y)+1;
V(count)<+n;
end
endmodule
