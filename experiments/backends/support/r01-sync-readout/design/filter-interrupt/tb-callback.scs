simulator lang=spectre
global 0
ahdl_include "dut-callback.va"
X_DUT (h edge y qout count f) product_card
simulatorOptions options reltol=1e-9 vabstol=1e-11 iabstol=1e-15 precision="%24.17g"
tran tran stop=2.86102294921875e-06 maxstep=7.4505805969238281e-09 errpreset=conservative method=gear2only strobeoutput=all strobetimes=[0 2e-12 1.4901161193847656e-08 2.9802322387695312e-08 4.4703483581542969e-08 5.9604644775390625e-08 7.4505805969238281e-08 8.9406967163085938e-08 1.0430812835693359e-07 1.1920928955078125e-07 1.3411045074462891e-07 1.4901161193847656e-07 1.6391277313232422e-07 1.7881393432617188e-07 1.9371509552001953e-07 2.0861625671386719e-07 2.2351741790771484e-07 2.384185791015625e-07 2.5331974029541016e-07 2.6822090148925781e-07 2.8312206268310547e-07 2.9802322387695312e-07 3.1292438507080078e-07 3.2782554626464844e-07 3.4272670745849609e-07 3.5762786865234375e-07 3.7252902984619141e-07 3.8743019104003906e-07 4.0233135223388672e-07 4.1723251342773438e-07 4.3213367462158203e-07 4.4703483581542969e-07 4.6193599700927734e-07 4.76837158203125e-07 4.9173831939697266e-07 5.0663948059082031e-07 5.2154064178466797e-07 5.3644180297851562e-07 5.5134296417236328e-07 5.6624412536621094e-07 5.8114528656005859e-07 5.9604644775390625e-07 6.1094760894775391e-07 6.2584877014160156e-07 6.4074993133544922e-07 6.5565109252929688e-07 6.7055225372314453e-07 6.8545341491699219e-07 7.0035457611083984e-07 7.152557373046875e-07 7.3015689849853516e-07 7.4505805969238281e-07 7.5995922088623047e-07 7.7486038208007812e-07 7.8976154327392578e-07 8.0466270446777344e-07 8.1956386566162109e-07 8.3446502685546875e-07 8.4936618804931641e-07 8.6426734924316406e-07 8.7916851043701172e-07 8.9406967163085938e-07 9.0897083282470703e-07 9.2387199401855469e-07 9.3877315521240234e-07 9.5367231640625005e-07 9.5367431640624989e-07 9.5367431640625e-07 9.5367431640625021e-07 9.5367631640625006e-07 9.6857547760009766e-07 9.8347663879394531e-07 9.9837779998779297e-07 1.0132789611816406e-06 1.0281801223754883e-06 1.0430812835693359e-06 1.0579824447631836e-06 1.0728836059570312e-06 1.0877847671508789e-06 1.1026859283447266e-06 1.1175870895385742e-06 1.1324882507324219e-06 1.1473894119262695e-06 1.1622905731201172e-06 1.1771917343139648e-06 1.1920928955078125e-06 1.2069940567016602e-06 1.2218952178955078e-06 1.2367963790893555e-06 1.2516975402832031e-06 1.2665987014770508e-06 1.2814998626708984e-06 1.2964010238647461e-06 1.3113021850585938e-06 1.3262033462524414e-06 1.3411045074462891e-06 1.3560056686401367e-06 1.3709068298339844e-06 1.385807991027832e-06 1.4007091522216797e-06 1.4156103134155273e-06 1.4305094746093749e-06 1.4305114746093748e-06 1.430511474609375e-06 1.4305114746093752e-06 1.4305134746093751e-06 1.4454126358032227e-06 1.4603137969970703e-06 1.475214958190918e-06 1.4901161193847656e-06 1.5050172805786133e-06 1.5199184417724609e-06 1.5348196029663086e-06 1.5497207641601562e-06 1.5646219253540039e-06 1.5795230865478516e-06 1.5944242477416992e-06 1.6093254089355469e-06 1.6242265701293945e-06 1.6391277313232422e-06 1.6540288925170898e-06 1.6689300537109375e-06 1.6838312149047852e-06 1.6987323760986328e-06 1.7136335372924805e-06 1.7285346984863281e-06 1.7434358596801758e-06 1.7583370208740234e-06 1.7732381820678711e-06 1.7881393432617188e-06 1.8030405044555664e-06 1.8179416656494141e-06 1.8328428268432617e-06 1.8477439880371094e-06 1.862645149230957e-06 1.8775463104248047e-06 1.8924474716186523e-06 1.9073466328124999e-06 1.9073486328124998e-06 1.9073486328125e-06 1.9073486328125004e-06 1.9073506328125001e-06 1.9222497940063477e-06 1.9371509552001953e-06 1.952052116394043e-06 1.9669532775878906e-06 1.9818544387817383e-06 1.9967555999755859e-06 2.0116567611694336e-06 2.0265579223632812e-06 2.0414590835571289e-06 2.0563602447509766e-06 2.0712614059448242e-06 2.0861625671386719e-06 2.1010637283325195e-06 2.1159648895263672e-06 2.1308660507202148e-06 2.1457672119140625e-06 2.1606683731079102e-06 2.1755695343017578e-06 2.1904706954956055e-06 2.2053718566894531e-06 2.2202730178833008e-06 2.2351741790771484e-06 2.2500753402709961e-06 2.2649765014648438e-06 2.2798776626586914e-06 2.2947788238525391e-06 2.3096799850463867e-06 2.3245811462402344e-06 2.339482307434082e-06 2.3543834686279297e-06 2.3692846298217773e-06 2.384185791015625e-06 2.3990869522094727e-06 2.4139881134033203e-06 2.428889274597168e-06 2.4437904357910156e-06 2.4586915969848633e-06 2.4735927581787109e-06 2.4884939193725586e-06 2.5033950805664062e-06 2.5182962417602539e-06 2.5331974029541016e-06 2.5480985641479492e-06 2.5629997253417969e-06 2.5779008865356445e-06 2.5928020477294922e-06 2.6077032089233398e-06 2.6226043701171875e-06 2.6375055313110352e-06 2.6524066925048828e-06 2.6673078536987305e-06 2.6822090148925781e-06 2.6971101760864258e-06 2.7120113372802734e-06 2.7269124984741211e-06 2.7418136596679688e-06 2.7567148208618164e-06 2.7716159820556641e-06 2.7865171432495117e-06 2.8014183044433594e-06 2.816319465637207e-06 2.8312206268310547e-06 2.8461217880249023e-06 2.8610209492187499e-06 2.86102294921875e-06]
save h edge y qout count f
