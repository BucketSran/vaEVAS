`include "disciplines.vams"
module m(u,y,z,w,d,r); input u; output y,z,w,d; inout r; electrical u,y,z,w,d,r; integer n,k; real q;
analog begin @(initial_step) begin n=1; n=n+1; if(n==2 && V(u,r)>0)n=n+3;else n=7; k=-7; end V(y,r)<+n; V(z,r)<+k/2; V(w,r)<+k%2; V(d,r)<+q; end endmodule
