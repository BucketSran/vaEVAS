simulator lang=spectre
ahdl_include "dut.va"
VU (u 0) vsource type=pwl wave=[0 1 1 1]
Xdut (u y z w d 0) m
simulatorOptions options reltol=1e-10 vabstol=1e-12 iabstol=1e-15
tran tran stop=1 maxstep=0.0001220703125 errpreset=conservative strobetimes=[0 .25 .5 .75 1]
save u y z w d
