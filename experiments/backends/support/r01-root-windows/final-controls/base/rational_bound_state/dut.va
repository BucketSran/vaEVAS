`include "disciplines.vams"
module m(u,y,r); input u; output y; inout r; electrical u,y,r; real q;
analog begin @(initial_step)q=0.125; @(timer(0.5,0,0))q=0.0625; $bound_step(q); V(y,r)<+idt(1/(1+V(u,r)*V(u,r)),0); end endmodule
