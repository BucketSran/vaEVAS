`include "disciplines.vams"
module m(u,y,r); input u; output y; inout r; electrical u,y,r; integer n;
analog begin @(initial_step)n=1; @(timer(0.5,0,0))begin $display("BASE before %.17g %d",$abstime,n);n=n+1;$display("BASE after %.17g %d",$abstime,n);end @(timer(1,0,0))n=7; @(final_step)$display("BASE final %.17g %d",$abstime,n); V(y,r)<+n+idt(1,0); end endmodule
