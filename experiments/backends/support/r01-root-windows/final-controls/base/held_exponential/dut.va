`include "disciplines.vams"
module m(u,y,r); input u; output y; inout r; electrical u,y,r; real q;
analog begin @(initial_step)q=0; @(timer(0.5,0,0))q=0.5; V(y,r)<+idt(exp(-(V(u,r)-q)),0); end endmodule
