simulator lang=spectre
ahdl_include "dut.va"
Vu (u 0) vsource type=pwl wave=[0 0 9.9999999999999995e-08 0 1.002e-07 1.8 1.9999999999999999e-07 1.8]
dut (u y z w 0) m
simulatorOptions options precision="%.17g" reltol=1e-9 vabstol=1e-12 iabstol=1e-15
tran tran stop=1.9999999999999999e-07 maxstep=7e-11 method=traponly errpreset=conservative compression=no strobeoutput=all strobetimes=[0 4.9999999999999998e-08 9.9999999999999995e-08 1.002e-07 1.2499999999999999e-07 1.4999999999999999e-07 1.9999999999999999e-07]
save u y z w
