`include "disciplines.vams"
module m(u,y);input u;output y;electrical u,y;real q,h;analog begin h=idt(((V(u)>0.25?V(u):0.0)>0.5)?1.0:0.0,0.0); V(y)<+laplace_nd(h,'{1.0},'{1.0,0.125}); end endmodule
