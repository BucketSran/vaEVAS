simulator lang=spectre
ahdl_include "dut.va"
Vu (u 0) vsource type=pwl wave=[0 0 3e-8 0 3.02e-8 1.8 4e-8 1.8]
Xd (u y) endpoint_ns
simulatorOptions options reltol=1e-9 vabstol=1e-12 iabstol=1e-15 precision="%.17g"
tran tran stop=4e-8 maxstep=1e-10 method=traponly errpreset=conservative compression=no transres=1e-24 strobeoutput=all strobetimes=[0 3e-8 3.01e-8 3.02e-8 4e-8]
save u y
