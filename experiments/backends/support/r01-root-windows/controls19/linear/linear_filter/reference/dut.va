`include "disciplines.vams"
module m(u,y,r); input u; output y; inout r; electrical u,y,r; analog begin V(y,r)<+laplace_nd((V(u,r)<0.5)?2:-1,'{1.0},'{1.0,0.25}); end endmodule
