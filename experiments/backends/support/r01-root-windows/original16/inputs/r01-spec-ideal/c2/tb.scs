simulator lang=spectre
global 0
simulatorOptions options reltol=1e-6 vabstol=1e-9 iabstol=1e-15
ahdl_include "dut.va"
V_vin (vin 0) vsource type=pwl wave=[0 0.3 9.625e-08 0.3 9.645e-08 1.6 1.6585e-07 1.6 1.6605e-07 0.2 3.181e-07 0.2 3.183e-07 1.1 4.399e-07 1.1 4.401e-07 0.55 7.183e-07 0.55 7.185e-07 1.45]
V_rst (rst 0) vsource type=pwl wave=[0 0 3.1087e-08 0 3.1287e-08 1.8 4.666e-08 1.8 4.686e-08 0 3.355e-07 0 3.357e-07 1.8 3.4768e-07 1.8 3.4788e-07 0 5.704e-07 0 5.706e-07 1.8 5.8258e-07 1.8 5.8278e-07 0]
V_track (track 0) vsource type=pwl wave=[0 1.8 5.71e-08 1.8 5.73e-08 1.8 7.015e-08 1.8 7.035e-08 0 1.18e-07 0 1.182e-07 1.8 1.2496e-07 1.8 1.2516e-07 0 1.528e-07 0 1.53e-07 1.8 1.5715e-07 1.8 1.5735e-07 0 2.0935e-07 0 2.0955e-07 1.8 2.4415e-07 1.8 2.4435e-07 0 3.268e-07 0 3.27e-07 1.8 3.5725e-07 1.8 3.5745e-07 0 4.225e-07 0 4.227e-07 1.8 4.834e-07 1.8 4.836e-07 0 7.096e-07 0 7.098e-07 1.8 7.4875e-07 1.8 7.4895e-07 0]
X_DUT (vin track rst vout) r01_track_hold_ideal vinit=0.8
tran tran stop=8.14e-07 maxstep=100p errpreset=conservative
save vin rst track vout
