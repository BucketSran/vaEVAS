`include "disciplines.vams"
module load(ctrl,y);input ctrl;output y;electrical ctrl,y;integer q;analog begin @(initial_step) q=(V(ctrl)>0.5); V(y)<+q; end endmodule
module drive(ctrl);output ctrl;electrical ctrl;integer s;analog begin @(initial_step)s=1; V(ctrl)<+transition(s,0,0.1,0.1);end endmodule
