simulator lang=spectre
ahdl_include "dut.va"
Vinput (u 0) vsource type=pwl wave=[0 0 1 0.5]
Xdut (u y 0) m
simulatorOptions options precision="%.17g" reltol=1e-10 vabstol=1e-12 iabstol=1e-15
tran tran stop=1 maxstep=0.03125 method=traponly errpreset=conservative strobetimes=[0 1]
save u y
