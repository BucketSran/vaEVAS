simulator lang=spectre
ahdl_include "dut.va"
Vinput (u 0) vsource type=pwl wave=[0 0 9.9999999999999995e-07 1 3.0000000000000001e-06 1 3.9999999999999998e-06 -1 6.0000000000000002e-06 -1]
Xdut (u y 0) m
simulatorOptions options precision="%.17g" reltol=1e-10 vabstol=1e-12 iabstol=1e-15
tran tran stop=6.0000000000000002e-06 maxstep=5.0000000000000003e-10 method=traponly errpreset=conservative strobetimes=[0 4.9999999999999998e-07 9.9999999999999995e-07 1.9999999999999999e-06 3.0000000000000001e-06 3.9999999999999998e-06 6.0000000000000002e-06]
save u y
