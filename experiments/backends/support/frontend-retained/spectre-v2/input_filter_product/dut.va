`include "disciplines.vams"
module m(u,y,r); input u; output y; inout r; electrical u,y,r; electrical z; real q; analog begin V(y,r)<+laplace_nd(V(u,r),'{1.0},'{1.0,0.5e-6})*V(u,r); end endmodule
