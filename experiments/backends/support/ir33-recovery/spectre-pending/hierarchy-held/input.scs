simulator lang=spectre
ahdl_include "model.va"
dut (a b x y) top
Va (a 0) vsource type=pwl wave=[0 0 1 1 2 0 6 0]
Vb (b 0) vsource type=pwl wave=[0 0 3 0 4 1 5 0 6 0]
opts options reltol=1e-6 vabstol=1e-9 iabstol=1e-12
tran tran stop=6 maxstep=0.01 errpreset=conservative strobeoutput=all strobetimes=[0 2.5 6]
save x y
