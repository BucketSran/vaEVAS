`include "disciplines.vams"
module leaf(s,y);input s;output y;electrical s,y;parameter real seed=7;real q;analog begin @(initial_step)q=seed;if(V(s)>0.5)q=1;V(y)<+q;end endmodule
module top(a,b,x,y);input a,b;output x,y;electrical a,b,x,y;leaf #(.seed(7)) first(a,x);leaf #(.seed(9)) second(b,y);endmodule
