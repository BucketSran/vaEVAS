`include "disciplines.vams"
module mixed(u,y,z,r);
input u; output y,z; inout r; electrical u,y,z,r;
integer n,k,m,h; real due;
analog begin
@(initial_step) begin n=0;k=0;m=0;h=0;due=0.9;end
@(cross(V(u,r)-0.5,1,1e-12,1e-9)) begin n=n+1; due=0.75;  end
@(timer(0.5,0,1e-12)) begin k=k+1;  end
@(cross(V(u,r)-0.5000000000000001,1,1e-12,1e-9)) begin m=m+1;  end
@(timer(due,0,1e-12)) begin h=h+1; end
V(y,r)<+n+10*k+100*m+1000*h;
V(z,r)<+idt(1,0);
end endmodule
