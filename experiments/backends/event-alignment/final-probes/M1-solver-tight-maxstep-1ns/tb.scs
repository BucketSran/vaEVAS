simulator lang=spectre
ahdl_include "dut.va"
V0 (u 0) vsource type=pwl wave=[0 0 9.9999999999999991e-06 10]
V1 (clk 0) vsource type=pwl wave=[0 0 9.9999999999999991e-06 10]
Xdut (u clk y z q n m s h1 h2 h3 0) probe
simulatorOptions options reltol=1e-12 vabstol=1e-15 iabstol=1.0000000000000001e-15 precision="%24.17g" saveahdlvars=allwithnodes
tran tran stop=9.9999999999999991e-06 maxstep=1e-9 method=traponly strobeoutput=all strobetimes=[0 6.2499999999999997e-08 1.2499999999999999e-07 1.875e-07 2.4999999999999999e-07 3.1249999999999997e-07 3.7500000000000001e-07 4.3749999999999999e-07 4.9999999999999998e-07 5.6250000000000001e-07 6.2499999999999995e-07 6.8749999999999998e-07 7.5000000000000002e-07 8.1249999999999995e-07 8.7499999999999999e-07 9.3749999999999992e-07 9.9999999999999995e-07 1.0625e-06 1.125e-06 1.1874999999999999e-06 1.2499999999999999e-06 1.3124999999999999e-06 1.375e-06 1.4375e-06 1.5e-06 1.5624999999999999e-06 1.6249999999999999e-06 1.6874999999999999e-06 1.75e-06 1.8125e-06 1.8749999999999998e-06 1.9375000000000001e-06 1.9999979999999999e-06 1.9999999999999999e-06 2.000002e-06 2.0624999999999997e-06 2.125e-06 2.1874999999999998e-06 2.249998e-06 2.2500000000000001e-06 2.2500020000000001e-06 2.3124999999999999e-06 2.3749999999999997e-06 2.4375e-06 2.4999999999999998e-06 2.5625e-06 2.6249999999999999e-06 2.6874999999999997e-06 2.7499999999999999e-06 2.8124999999999998e-06 2.875e-06 2.9374999999999998e-06 3.0000000000000001e-06 3.0624999999999999e-06 3.1249999999999997e-06 3.1875e-06 3.2499979999999997e-06 3.2499999999999998e-06 3.2500019999999999e-06 3.3125e-06 3.3749999999999999e-06 3.4374999999999997e-06 3.4999999999999999e-06 3.5624999999999998e-06 3.625e-06 3.6874999999999998e-06 3.7499999999999997e-06 3.8124999999999999e-06 3.8750000000000002e-06 3.9375e-06 3.9999999999999998e-06 4.0624999999999996e-06 4.1249999999999995e-06 4.1875000000000001e-06 4.25e-06 4.3124999999999998e-06 4.3749999999999996e-06 4.4374999999999994e-06 4.5000000000000001e-06 4.5624999999999999e-06 4.6249999999999998e-06 4.6874999999999996e-06 4.7499999999999994e-06 4.8125000000000001e-06 4.8749999999999999e-06 4.9374999999999997e-06 4.9999999999999996e-06 5.0624999999999994e-06 5.1250000000000001e-06 5.1874999999999999e-06 5.2499999999999997e-06 5.3124999999999995e-06 5.3749999999999994e-06 5.4375e-06 5.4999999999999999e-06 5.5624999999999997e-06 5.6249999999999995e-06 5.6874999999999993e-06 5.75e-06 5.8124999999999998e-06 5.8749999999999997e-06 5.9374999999999995e-06 5.9999980000000005e-06 6.0000000000000002e-06 6.0000019999999998e-06 6.0625e-06 6.1249999999999998e-06 6.1874999999999996e-06 6.2499979999999998e-06 6.2499999999999995e-06 6.2500019999999991e-06 6.3125000000000001e-06 6.3749999999999999e-06 6.4374999999999998e-06 6.4999999999999996e-06 6.5624999999999994e-06 6.6250000000000001e-06 6.6874999999999999e-06 6.7499999999999997e-06 6.8124999999999996e-06 6.8749999999999994e-06 6.9375000000000001e-06 6.9999999999999999e-06 7.0624999999999997e-06 7.1249999999999995e-06 7.1874999999999994e-06 7.25e-06 7.3124999999999999e-06 7.3749999999999997e-06 7.4374999999999995e-06 7.4999999999999993e-06 7.5625e-06 7.6249999999999998e-06 7.6874999999999988e-06 7.7500000000000003e-06 7.8125000000000002e-06 7.875e-06 7.9374999999999998e-06 7.9999999999999996e-06 8.0624999999999995e-06 8.1249999999999993e-06 8.1874999999999991e-06 8.2499979999999985e-06 8.2499999999999989e-06 8.2500019999999994e-06 8.3125000000000005e-06 8.3750000000000003e-06 8.4375000000000001e-06 8.4999999999999999e-06 8.5624999999999998e-06 8.6249999999999996e-06 8.6874999999999994e-06 8.7499999999999992e-06 8.8124999999999991e-06 8.8749999999999989e-06 8.9375000000000004e-06 9.0000000000000002e-06 9.0625000000000001e-06 9.1249999999999999e-06 9.1874999999999997e-06 9.2499999999999995e-06 9.3124999999999994e-06 9.3749999999999992e-06 9.437499999999999e-06 9.4999999999999988e-06 9.5625000000000003e-06 9.6250000000000002e-06 9.6875e-06 9.7499999999999998e-06 9.8124999999999996e-06 9.8749999999999995e-06 9.9374999999999993e-06 9.9999999999999991e-06]
save u clk y z q n m s h1 h2 h3
