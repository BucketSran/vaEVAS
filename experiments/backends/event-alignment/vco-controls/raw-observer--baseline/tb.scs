simulator lang=spectre
global 0
ahdl_include "dut.va"
vctl (ctl 0) vsource dc=0
dut (ctl freq phase out raw) phase_observer
opts options reltol=1.0000000000000001e-05 vabstol=9.9999999999999995e-08 iabstol=9.9999999999999998e-13 precision="%24.17g"
tran tran stop=7.62939453125e-6 maxstep=2.3283064365386963e-10 errpreset=conservative method=traponly strobetimes=[0 1.6689291442162357e-06 1.6689300537109373e-06 1.6689300537109375e-06 1.6689300537109377e-06 1.6689309632056393e-06 3.5762777770287357e-06 3.5762786865234371e-06 3.5762786865234375e-06 3.5762786865234379e-06 3.5762795960181393e-06 5.4836264098412357e-06 5.4836273193359367e-06 5.4836273193359375e-06 5.4836273193359383e-06 5.4836282288306393e-06 7.3909750426537357e-06 7.3909759521484367e-06 7.3909759521484375e-06 7.3909759521484383e-06 7.3909768616431393e-06 7.62939453125e-06] strobeoutput=all
save ctl freq phase out raw
