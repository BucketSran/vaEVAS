`include "disciplines.vams"
`include "constants.vams"
// Original voltage-domain PLL stimulus oscillator. The step bound follows the current
// frequency while preserving the same samples per cycle across its tuning range.
module tuning_vco(control, out);
  input control;
  output out;
  electrical control, out;
  parameter real fmin=4e6 from (0:inf);
  parameter real fmax=400e6 from (0:inf);
  parameter real amplitude=0.5 from (0:inf);
  parameter real offset=0.6;
  parameter integer points_per_cycle=64 from [16:256];
  real frequency, phase;
  analog begin
    frequency=fmin+(fmax-fmin)*min(1.0,max(0.0,V(control)));
    phase=idtmod(frequency,0.0,1.0);
    $bound_step(1.0/(points_per_cycle*frequency));
    V(out) <+ offset+0.9*amplitude*sin(2.0*`M_PI*phase);
  end
endmodule
