`include "constants.vams"
`include "disciplines.vams"
module iq_mixer(i,q,lc,ls,rf,en,up,di,dq);
inout i,q,lc,ls,rf,en,up,di,dq;
electrical i,q,lc,ls,rf,en,up,di,dq;
parameter real gain=1, fbw=2000;
electrical a,b;
analog begin
V(a) <+ idt(2*`M_PI*fbw*(2*V(rf)*V(lc)-V(a)),0);
V(b) <+ idt(2*`M_PI*fbw*(-2*V(rf)*V(ls)-V(b)),0);
V(up) <+ (V(en)>0.5) ? gain*(V(i)*V(lc)-V(q)*V(ls)) : 0;
V(di) <+ (V(en)>0.5) ? 2*V(rf)*V(lc) : 0;
V(dq) <+ (V(en)>0.5) ? V(b) : 0;
end
endmodule
