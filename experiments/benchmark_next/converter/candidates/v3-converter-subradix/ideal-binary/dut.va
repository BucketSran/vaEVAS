`include "disciplines.vams"
module dut(vd0,vd1,vd2,vd3,vd4,vd5,vd6,vd7,vd8,vd9,clk,rst,aout);
inout vd0,vd1,vd2,vd3,vd4,vd5,vd6,vd7,vd8,vd9,clk,rst,aout;electrical vd0,vd1,vd2,vd3,vd4,vd5,vd6,vd7,vd8,vd9,clk,rst,aout;
parameter real lo=0, hi=1, tr=100p;
real q,weighted;
analog begin
 @(initial_step) q=lo;
 @(cross(V(clk)-0.5,+1)) begin
  weighted=1*(V(vd0)>0.45)+2*(V(vd1)>0.45)+4*(V(vd2)>0.45)+8*(V(vd3)>0.45)+16*(V(vd4)>0.45)+32*(V(vd5)>0.45)+64*(V(vd6)>0.45)+128*(V(vd7)>0.45)+256*(V(vd8)>0.45)+512*(V(vd9)>0.45);
  q=lo+(hi-lo)*weighted/1023;
 end
 V(aout)<+transition(q,0,tr,tr);
end
endmodule
