`include "constants.vams"
`include "disciplines.vams"
module dut(code,clk,rst,sample_ok,sndr,sfdr,dc,enob,valid);
inout code,clk,rst,sample_ok,sndr,sfdr,dc,enob,valid;electrical code,clk,rst,sample_ok,sndr,sfdr,dc,enob,valid;
parameter integer tone_bin=5;
real cs[0:32],ss[0:32],x,p,fund,spurious,noise,sum,out_sndr,out_sfdr,out_dc;
integer n,k,bad,ok;
analog begin
 @(initial_step)begin n=0;sum=0;out_sndr=0;out_sfdr=0;out_dc=0;bad=0;ok=0;for(k=0;k<=32;k=k+1)begin cs[k]=0;ss[k]=0;end end
 @(cross(V(rst)-0.5,+1))begin n=0;sum=0;out_sndr=0;out_sfdr=0;out_dc=0;bad=0;ok=0;for(k=0;k<=32;k=k+1)begin cs[k]=0;ss[k]=0;end end
 @(cross(V(clk)-0.5,+1))begin
  if(V(rst)<0.5 && n<64)begin
   x=V(code);if(V(sample_ok)<0.5 || x<0 || x>4095 || abs(x-floor(x+0.5))>0.0001)bad=1;sum=sum+x;
   for(k=0;k<=32;k=k+1)begin cs[k]=cs[k]+x*cos(2*3.1415926535897932384626433832795*k*n/64.0);ss[k]=ss[k]+x*sin(2*3.1415926535897932384626433832795*k*n/64.0);end
   n=n+1;
   if(n==64)begin
    fund=2*(cs[tone_bin]*cs[tone_bin]+ss[tone_bin]*ss[tone_bin]+cs[2*tone_bin]*cs[2*tone_bin]+ss[2*tone_bin]*ss[2*tone_bin])/4096;
    noise=0;spurious=0;
    for(k=1;k<=32;k=k+1)if(k!=tone_bin && k!=2*tone_bin)begin
     p=2*(cs[k]*cs[k]+ss[k]*ss[k])/4096;if(k==32)p=p/2;
     noise=noise+p;if(p>spurious)spurious=p;
    end
    if(!bad && fund>1e-8 && noise>1e-8 && spurious>1e-8)begin out_sndr=10*ln(fund/noise)/ln(10);out_sfdr=10*ln(fund/spurious)/ln(10);out_dc=sum/64;ok=1;end
   end
  end
 end
 V(valid)<+ok;V(enob)<+(ok?(out_sndr-1.76)/6.02:0);
 V(sndr)<+out_sndr;V(sfdr)<+out_sfdr;V(dc)<+out_dc;
end
endmodule
