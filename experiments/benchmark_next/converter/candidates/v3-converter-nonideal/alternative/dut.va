`include "disciplines.vams"
module dut(b0,b1,b2,b3,clk,rst,aout);
inout b0,b1,b2,b3,clk,rst,aout;electrical b0,b1,b2,b3,clk,rst,aout;
parameter real lo=0, hi=1, tr=100p;
real q,weighted;
analog begin
 @(initial_step) q=lo;
 @(cross(V(clk)-0.5,+1)) begin
  weighted=1*((V(b0)>0.45)?1.0:-1.0)+2.02*((V(b1)>0.45)?1.0:-1.0)+3.96*((V(b2)>0.45)?1.0:-1.0)+8.08*((V(b3)>0.45)?1.0:-1.0);
  q=(hi+lo)/2+(hi-lo)*weighted/30.12;
 end
 V(aout)<+transition(q,0,tr,tr);
end
endmodule
