`include "disciplines.vams"
module dut(code,observe,clk,rst,dnl,inl,valid);
inout code,observe,clk,rst,dnl,inl,valid;electrical code,observe,clk,rst,dnl,inl,valid;
real x[0:15],step,a,b,od,oi,cumulative;integer n,k,bad,ok;
analog begin
 @(initial_step) begin n=0;bad=0;ok=0;od=0;oi=0;end
 @(cross(V(rst)-0.5,+1)) begin n=0;bad=0;ok=0;od=0;oi=0;end
 @(cross(V(clk)-0.5,+1)) if(V(rst)<0.5 && n<16) begin
  if(abs(V(code)-n)>0.001) bad=1;
  x[n]=V(observe);n=n+1;
  if(n==16 && !bad) begin
   step=(x[15]-x[0])/15;
   if(step>0) begin
    cumulative=0;
    for(k=1;k<16;k=k+1) begin
     b=(x[k]-x[k-1])/step-1;
     cumulative=cumulative+b;
     if(abs(b)>od)od=abs(b);
     if(abs(cumulative)>oi)oi=abs(cumulative);
    end
    ok=1;
   end
  end
 end
 V(dnl)<+od;V(inl)<+oi;V(valid)<+ok;
end
endmodule
