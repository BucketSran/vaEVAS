`include "constants.vams"
`include "disciplines.vams"
module calibration_controller(outp,outn,cal,enable,rst,code);
input outp,outn,cal,enable,rst;output code;electrical outp,outn,cal,enable,rst,code;
parameter real mode=0;
integer value;real error,next;
analog begin
 @(initial_step)value=0;
 @(cross(V(rst)-0.45,+1))value=0;
 @(timer(1u,2u))begin
  if(V(rst)>0.45)value=0;
  else if(V(enable)>0.45 && (mode>0.5 || V(cal)>0.45))begin
   if(mode<0.5)error=V(outp,outn);else error=(V(outp)+V(outn))*0.5-0.5;
   if(error>0.015)next=value-8;else if(error< -0.015)next=value+8;else if(error>0.0015)next=value-2;else if(error< -0.0015)next=value+2;else next=value;
   if(next>=0)value=$rtoi(next+0.5);else value=-$rtoi(-next+0.5);
   if(value>64)value=64;if(value< -64)value=-64;
  end
 end
 V(code)<+transition(value,0,100n);
end
endmodule
