`include "disciplines.vams"
// Full POR bench: supply follows observed completion / power-loss events.
module por_bench(avdd, por, power, osc, first_response_us, first_period_us, first_width_us, first_valid, first_ok, recovery_response_us, recovery_period_us, recovery_width_us, recovery_valid, recovery_ok, done);
output avdd,first_response_us,first_period_us,first_width_us,first_valid,first_ok,recovery_response_us,recovery_period_us,recovery_width_us,recovery_valid,recovery_ok,done;
input por,power,osc;
electrical avdd,por,power,osc,first_response_us,first_period_us,first_width_us,first_valid,first_ok,recovery_response_us,recovery_period_us,recovery_width_us,recovery_valid,recovery_ok,done;
parameter real tick=500n, ramp=2m, dip_ramp=100u, hold=100u, recovery_ramp=100u, timeout=1m, tr=100p;
integer state,cycle,n[0:1],rising_count[0:1],falling_count[0:1],saw_rise[0:1],saw_fall[0:1],lost,finished,v[0:1],ok[0:1],i;
real t0[0:1],t3[0:1],t9[0:1],previous[0:1],sum_period[0:1],pr[0:1],pf[0:1],response[0:1],period[0:1],width[0:1],phase_time,lost_time,supply,last_clock[0:1];
analog begin
 @(initial_step) begin
  state=0;cycle=0;lost=0;finished=0;phase_time=0;lost_time=0;
  for(i=0;i<2;i=i+1) begin n[i]=0;rising_count[i]=0;falling_count[i]=0;saw_rise[i]=0;saw_fall[i]=0;t0[i]=0;t3[i]=0;t9[i]=0;previous[i]=0;sum_period[i]=0;last_clock[i]=0;pr[i]=0;pf[i]=0;response[i]=0;period[i]=0;width[i]=0;v[i]=0;ok[i]=0;end
 end
 @(cross(V(power)-0.9,-1)) begin lost=1;lost_time=$abstime;end
 @(cross(V(power)-0.9,+1)) begin
  if(state>=3) cycle=1;
 end
 @(cross(V(osc)-0.9,+1)) begin
  if((cycle==1 || state==0) && V(power)>0.9) begin
   n[cycle]=n[cycle]+1;last_clock[cycle]=$abstime;
   if(n[cycle]==1) t0[cycle]=$abstime;
   if(n[cycle]>3 && n[cycle]<=9) sum_period[cycle]=sum_period[cycle]+$abstime-previous[cycle];previous[cycle]=$abstime;
   if(n[cycle]==9) t9[cycle]=$abstime;
  end
 end
 @(cross(V(por)-0.9,+1)) begin
  if((cycle==1 || state==0) && !saw_rise[cycle]) begin saw_rise[cycle]=1;pr[cycle]=$abstime;rising_count[cycle]=n[cycle];end
 end
 @(cross(V(por)-0.9,-1)) begin
  if((cycle==1 || state==0) && saw_rise[cycle] && !saw_fall[cycle]) begin saw_fall[cycle]=1;pf[cycle]=$abstime;falling_count[cycle]=n[cycle];end
 end
 @(timer(0,tick)) begin
  if(state==0 && $abstime+1f>=ramp+hold && ((saw_fall[0] && pf[0]<ramp+timeout && $abstime+1f>=pf[0]+hold) || ((!saw_fall[0] || pf[0]>=ramp+timeout) && $abstime+1f>=ramp+timeout))) begin
   state=1;phase_time=$abstime;
   // Exclude an event at dip even if its cross callback ran before this timer.
   if(saw_rise[0] && pr[0]>=phase_time) saw_rise[0]=0;
   if(saw_fall[0] && pf[0]>=phase_time) saw_fall[0]=0;
   if(n[0]>0 && last_clock[0]>=phase_time) n[0]=n[0]-1;
  end
  else if(state==1 && $abstime+1f>=phase_time+dip_ramp) begin state=2;phase_time=$abstime;end
  else if(state==2 && ((lost && lost_time<phase_time+timeout && $abstime+1f>=phase_time+hold && $abstime+1f>=lost_time+hold) || ((!lost || lost_time>=phase_time+timeout) && $abstime+1f>=phase_time+timeout))) begin state=3;phase_time=$abstime;cycle=1;end
  else if(state==3 && $abstime+1f>=phase_time+recovery_ramp) begin state=4;phase_time=$abstime;end
  else if(state==4 && ((saw_fall[1] && pf[1]<phase_time+timeout && $abstime+1f>=pf[1]+hold) || ((!saw_fall[1] || pf[1]>=phase_time+timeout) && $abstime+1f>=phase_time+timeout))) begin
   state=5;finished=1;
   for(i=0;i<2;i=i+1) begin
    v[i]=saw_rise[i] && saw_fall[i] && n[i]>=9;
    if(v[i]) begin response[i]=(pr[i]-t0[i])*1e6;period[i]=sum_period[i]*1e6/6;width[i]=(pf[i]-pr[i])*1e6;end
    ok[i]=v[i] && rising_count[i]==6 && falling_count[i]==13 && lost;
   end
   $strobe("POR_COMPLETE first_valid=%d first_ok=%d recovery_valid=%d recovery_ok=%d",v[0],ok[0],v[1],ok[1]);
  end
 end
 if(state==0) supply=3.3*min($abstime/ramp,1.0);
 else if(state==1) supply=3.3-1.3*min(($abstime-phase_time)/dip_ramp,1.0);
 else if(state==2) supply=2.0;
 else if(state==3) supply=2.0+1.3*min(($abstime-phase_time)/recovery_ramp,1.0);
 else supply=3.3;
 V(avdd)<+supply;
 V(first_response_us)<+transition(response[0],0,tr,tr);V(first_period_us)<+transition(period[0],0,tr,tr);V(first_width_us)<+transition(width[0],0,tr,tr);V(first_valid)<+transition(v[0],0,tr,tr);V(first_ok)<+transition(ok[0],0,tr,tr);
 V(recovery_response_us)<+transition(response[1],0,tr,tr);V(recovery_period_us)<+transition(period[1],0,tr,tr);V(recovery_width_us)<+transition(width[1],0,tr,tr);V(recovery_valid)<+transition(v[1],0,tr,tr);V(recovery_ok)<+transition(ok[1],0,tr,tr);V(done)<+transition(finished,0,tr,tr);
end
endmodule
