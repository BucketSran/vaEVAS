`include "constants.vams"
`include "disciplines.vams"

module gain_estimator(VDD, VSS, vinp, vinn, voutp, voutn, gain_out, valid, begin_round);
    inout VDD, VSS;
    input vinp, vinn, voutp, voutn, begin_round;
    output gain_out, valid;
    electrical VDD, VSS, vinp, vinn, voutp, voutn, gain_out, valid, begin_round;

    parameter real sample_period = 1n from (0:inf);
    parameter real start_time = 20n;
    parameter real gain_scale = 10.0 from (0:inf);
    parameter real min_input_span = 0.02 from (0:inf);
    parameter real tedge = 200p from (0:inf);

    real in_min, in_max;
    real out_min, out_max;
    real in_span, out_span;
    real gain_q;
    integer valid_q; integer ready;
    real vin_diff, vout_diff;

    analog begin
        @(initial_step) begin
            in_min = 1.0e9;
            in_max = -1.0e9;
            out_min = 1.0e9;
            out_max = -1.0e9;
            gain_q = 0.0; ready=0;
            valid_q = 0;
        end

        @(cross(V(begin_round)-0.5,+1)) begin
            in_min = 1.0e9;
            in_max = -1.0e9;
            out_min = 1.0e9;
            out_max = -1.0e9;
            gain_q = 0.0; ready=0;
            valid_q = 0;
        end

        @(timer(0, sample_period)) begin
            if ($abstime >= start_time) begin
                vin_diff = V(vinp, vinn);
                if(!ready) begin in_min=vin_diff; in_max=vin_diff; out_min=V(voutp,voutn); out_max=out_min; ready=1; end
                vout_diff = V(voutp, voutn);
                in_min=min(in_min,vin_diff);
                in_max=max(in_max,vin_diff);
                out_min=min(out_min,vout_diff);
                out_max=max(out_max,vout_diff);

                in_span = in_max - in_min;
                out_span = out_max - out_min;
                if (in_span > min_input_span) begin
                    gain_q = out_span / in_span;
                    valid_q = 1;
                end
            end
        end

        V(gain_out, VSS) <+ V(VDD, VSS) * transition(gain_q / gain_scale, 0, tedge, tedge);
        V(valid, VSS) <+ V(VDD, VSS) * transition(valid_q ? 1.0 : 0.0, 0, tedge, tedge);
    end
endmodule
