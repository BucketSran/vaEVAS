`include "constants.vams"
`include "disciplines.vams"

module duty_cycle_meter_8b(clk_in, valid, duty0, duty1, duty2, duty3, duty4, duty5, duty6, duty7);
    input clk_in;
    output valid, duty0, duty1, duty2, duty3, duty4, duty5, duty6, duty7;
    electrical clk_in, valid, duty0, duty1, duty2, duty3, duty4, duty5, duty6, duty7;

    parameter real vdd = 0.9;
    parameter real vth = 0.45;
    parameter real tr = 20p;

    real rise_t; real fall_t; real high_time; integer have_fall; integer have_rise; integer code; real valid_level;
    analog begin
        @(initial_step) begin rise_t=0; fall_t=0; have_fall=0; have_rise=0; code=0; valid_level=0; end
        @(cross(V(clk_in)-vth,+1)) begin if (have_rise && have_fall && $abstime > rise_t) begin code=floor(255.0*high_time/($abstime-rise_t)+0.5); if (code<0) code=0; if (code>255) code=255; valid_level=vdd; end rise_t=$abstime; have_rise=1; have_fall=0; end
        @(cross(V(clk_in)-vth,-1)) begin if(have_rise) begin fall_t=$abstime; high_time=$abstime-rise_t; have_fall=1; end end
        V(valid) <+ transition(valid_level, 0, tr, tr);
        V(duty0) <+ transition((((code) >> 0) & 1) ? vdd : 0.0, 0, tr, tr);
        V(duty1) <+ transition((((code) >> 1) & 1) ? vdd : 0.0, 0, tr, tr);
        V(duty2) <+ transition((((code) >> 2) & 1) ? vdd : 0.0, 0, tr, tr);
        V(duty3) <+ transition((((code) >> 3) & 1) ? vdd : 0.0, 0, tr, tr);
        V(duty4) <+ transition((((code) >> 4) & 1) ? vdd : 0.0, 0, tr, tr);
        V(duty5) <+ transition((((code) >> 5) & 1) ? vdd : 0.0, 0, tr, tr);
        V(duty6) <+ transition((((code) >> 6) & 1) ? vdd : 0.0, 0, tr, tr);
        V(duty7) <+ transition((((code) >> 7) & 1) ? vdd : 0.0, 0, tr, tr);
    end
endmodule
