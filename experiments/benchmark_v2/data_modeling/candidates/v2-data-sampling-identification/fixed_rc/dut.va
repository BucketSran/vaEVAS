`include "constants.vams"
`include "disciplines.vams"
module sampling_model(vin, clock, vhold);
input vin, clock; output vhold;
electrical vin, clock, vhold, invstate;
real vinit, gateinit, correction, rate, target, tau;
analog function real channel_n;
input u,y,g; real u,y,g;
real lo,hi,delta,over,drain;
begin
lo=min(u,y); hi=max(u,y); delta=hi-lo;
over=max(0.0,g-lo-0.9-5.74525975682e-20*(sqrt(0.7+lo)-sqrt(0.7)));
drain=min(delta,over);
if(delta>1e-8) channel_n=8.68950768676*(over-0.5*drain)*drain/delta*(1.0+1.90820421815e-22*delta)/(1.0+2.15815474565*over);
else channel_n=8.68950768676*over/(1.0+2.15815474565*over);
end
endfunction
analog function real channel_p;
input u,y,g; real u,y,g;
real lo,hi,delta,over,drain;
begin
lo=min(u,y); hi=max(u,y); delta=hi-lo;
over=max(0.0,hi-g-0.2-1.46884482886*(sqrt(2.5-hi)-sqrt(0.7)));
drain=min(delta,over);
if(delta>1e-8) channel_p=0.34283938012*(over-0.5*drain)*drain/delta*(1.0+0.0413635387959*delta)/(1.0+1.08093547196e-19*over);
else channel_p=0.34283938012*over/(1.0+1.08093547196e-19*over);
end
endfunction
analog function real adjust0;
input z; real z;
begin
if(z<=0.2) adjust0=1.1713642316;
else if(z<=0.25) adjust0=1.1713642316+(-0.0123442125627)*(z-0.2)/0.05;
else if(z<=0.3) adjust0=1.15902001904+(-0.0185305631143)*(z-0.25)/0.05;
else if(z<=0.35) adjust0=1.14048945592+(-0.0200732264233)*(z-0.3)/0.05;
else if(z<=0.4) adjust0=1.1204162295+(-0.0184275833354)*(z-0.35)/0.05;
else if(z<=0.45) adjust0=1.10198864616+(-0.0161426751689)*(z-0.4)/0.05;
else if(z<=0.5) adjust0=1.08584597099+(-0.0155096411365)*(z-0.45)/0.05;
else if(z<=0.55) adjust0=1.07033632986+(-0.0173783126781)*(z-0.5)/0.05;
else if(z<=0.6) adjust0=1.05295801718+(-0.0206810625359)*(z-0.55)/0.05;
else if(z<=0.65) adjust0=1.03227695464+(-0.0230276519087)*(z-0.6)/0.05;
else if(z<=0.7) adjust0=1.00924930274+(-0.0221544459459)*(z-0.65)/0.05;
else if(z<=0.75) adjust0=0.987094856789+(-0.0173239521798)*(z-0.7)/0.05;
else if(z<=0.8) adjust0=0.96977090461+(-0.00977320392135)*(z-0.75)/0.05;
else if(z<=0.85) adjust0=0.959997700688+(-0.00204583647217)*(z-0.8)/0.05;
else if(z<=0.9) adjust0=0.957951864216+(0.00331514185338)*(z-0.85)/0.05;
else if(z<=0.95) adjust0=0.961267006069+(0.00506351574718)*(z-0.9)/0.05;
else if(z<=1) adjust0=0.966330521817+(0.00385600961586)*(z-0.95)/0.05;
else if(z<=1.05) adjust0=0.970186531433+(0.00166813183048)*(z-1)/0.05;
else if(z<=1.1) adjust0=0.971854663263+(0.000303892933717)*(z-1.05)/0.05;
else if(z<=1.15) adjust0=0.972158556197+(0.000143126148615)*(z-1.1)/0.05;
else if(z<=1.2) adjust0=0.972301682345+(0.000112656313236)*(z-1.15)/0.05;
else if(z<=1.25) adjust0=0.972414338659+(-0.00119403865899)*(z-1.2)/0.05;
else if(z<=1.3) adjust0=0.9712203+(-0.00418550203885)*(z-1.25)/0.05;
else if(z<=1.35) adjust0=0.967034797961+(-0.00775093946428)*(z-1.3)/0.05;
else if(z<=1.4) adjust0=0.959283858496+(-0.00993843568957)*(z-1.35)/0.05;
else if(z<=1.45) adjust0=0.949345422807+(-0.00925996316728)*(z-1.4)/0.05;
else if(z<=1.5) adjust0=0.94008545964+(-0.00558464902103)*(z-1.45)/0.05;
else if(z<=1.55) adjust0=0.934500810619+(-8.37711498982e-05)*(z-1.5)/0.05;
else if(z<=1.6) adjust0=0.934417039469+(0.00549223700439)*(z-1.55)/0.05;
else adjust0=0.939909276473;
end
endfunction
analog function real adjust1;
input z; real z;
begin
if(z<=0.2) adjust1=1.16320512744;
else if(z<=0.25) adjust1=1.16320512744+(-0.0129013784027)*(z-0.2)/0.05;
else if(z<=0.3) adjust1=1.15030374904+(-0.0190036036284)*(z-0.25)/0.05;
else if(z<=0.35) adjust1=1.13130014541+(-0.0204395664999)*(z-0.3)/0.05;
else if(z<=0.4) adjust1=1.11086057891+(-0.0184937580492)*(z-0.35)/0.05;
else if(z<=0.45) adjust1=1.09236682086+(-0.0156219907224)*(z-0.4)/0.05;
else if(z<=0.5) adjust1=1.07674483014+(-0.0142296019238)*(z-0.45)/0.05;
else if(z<=0.55) adjust1=1.06251522822+(-0.0154991964341)*(z-0.5)/0.05;
else if(z<=0.6) adjust1=1.04701603178+(-0.0187356746147)*(z-0.55)/0.05;
else if(z<=0.65) adjust1=1.02828035717+(-0.0216737477748)*(z-0.6)/0.05;
else if(z<=0.7) adjust1=1.00660660939+(-0.02177859182)*(z-0.65)/0.05;
else if(z<=0.75) adjust1=0.984828017572+(-0.017801783638)*(z-0.7)/0.05;
else if(z<=0.8) adjust1=0.967026233934+(-0.0105580697816)*(z-0.75)/0.05;
else if(z<=0.85) adjust1=0.956468164152+(-0.0024922124542)*(z-0.8)/0.05;
else if(z<=0.9) adjust1=0.953975951698+(0.00360301176429)*(z-0.85)/0.05;
else if(z<=0.95) adjust1=0.957578963462+(0.00603546705391)*(z-0.9)/0.05;
else if(z<=1) adjust1=0.963614430516+(0.00508162430344)*(z-0.95)/0.05;
else if(z<=1.05) adjust1=0.96869605482+(0.00263574353197)*(z-1)/0.05;
else if(z<=1.1) adjust1=0.971331798352+(0.000741758029096)*(z-1.05)/0.05;
else if(z<=1.15) adjust1=0.972073556381+(0.000133083821641)*(z-1.1)/0.05;
else if(z<=1.2) adjust1=0.972206640203+(-3.74963917794e-05)*(z-1.15)/0.05;
else if(z<=1.25) adjust1=0.972169143811+(-0.00117564316833)*(z-1.2)/0.05;
else if(z<=1.3) adjust1=0.970993500642+(-0.00385597168011)*(z-1.25)/0.05;
else if(z<=1.35) adjust1=0.967137528962+(-0.00716862157834)*(z-1.3)/0.05;
else if(z<=1.4) adjust1=0.959968907384+(-0.00928182148132)*(z-1.35)/0.05;
else if(z<=1.45) adjust1=0.950687085903+(-0.00871083153688)*(z-1.4)/0.05;
else if(z<=1.5) adjust1=0.941976254366+(-0.00525367791873)*(z-1.45)/0.05;
else if(z<=1.55) adjust1=0.936722576447+(5.3487524565e-07)*(z-1.5)/0.05;
else if(z<=1.6) adjust1=0.936723111322+(0.00535962537044)*(z-1.55)/0.05;
else adjust1=0.942082736693;
end
endfunction
analog function real adjust2;
input z; real z;
begin
if(z<=0.2) adjust2=1.14760980743;
else if(z<=0.25) adjust2=1.14760980743+(-0.0120029748188)*(z-0.2)/0.05;
else if(z<=0.3) adjust2=1.13560683261+(-0.0182420766938)*(z-0.25)/0.05;
else if(z<=0.35) adjust2=1.11736475592+(-0.0202669841511)*(z-0.3)/0.05;
else if(z<=0.4) adjust2=1.09709777177+(-0.0188262966841)*(z-0.35)/0.05;
else if(z<=0.45) adjust2=1.07827147508+(-0.0158382209719)*(z-0.4)/0.05;
else if(z<=0.5) adjust2=1.06243325411+(-0.0134955931953)*(z-0.45)/0.05;
else if(z<=0.55) adjust2=1.04893766092+(-0.0132721780236)*(z-0.5)/0.05;
else if(z<=0.6) adjust2=1.03566548289+(-0.0151574933218)*(z-0.55)/0.05;
else if(z<=0.65) adjust2=1.02050798957+(-0.0175527135825)*(z-0.6)/0.05;
else if(z<=0.7) adjust2=1.00295527599+(-0.0181221576748)*(z-0.65)/0.05;
else if(z<=0.75) adjust2=0.984833118315+(-0.0152478304935)*(z-0.7)/0.05;
else if(z<=0.8) adjust2=0.969585287821+(-0.00912806657507)*(z-0.75)/0.05;
else if(z<=0.85) adjust2=0.960457221246+(-0.00176964807724)*(z-0.8)/0.05;
else if(z<=0.9) adjust2=0.958687573169+(0.00408382987747)*(z-0.85)/0.05;
else if(z<=0.95) adjust2=0.962771403047+(0.0064662937863)*(z-0.9)/0.05;
else if(z<=1) adjust2=0.969237696833+(0.00530566044328)*(z-0.95)/0.05;
else if(z<=1.05) adjust2=0.974543357276+(0.00234933798488)*(z-1)/0.05;
else if(z<=1.1) adjust2=0.976892695261+(-0.00019353947916)*(z-1.05)/0.05;
else if(z<=1.15) adjust2=0.976699155782+(-0.00124656923057)*(z-1.1)/0.05;
else if(z<=1.2) adjust2=0.975452586551+(-0.00137859920395)*(z-1.15)/0.05;
else if(z<=1.25) adjust2=0.974073987347+(-0.00194785290417)*(z-1.2)/0.05;
else if(z<=1.3) adjust2=0.972126134443+(-0.00373532788853)*(z-1.25)/0.05;
else if(z<=1.35) adjust2=0.968390806555+(-0.00618591782443)*(z-1.3)/0.05;
else if(z<=1.4) adjust2=0.96220488873+(-0.00779067175251)*(z-1.35)/0.05;
else if(z<=1.45) adjust2=0.954414216978+(-0.00720634563947)*(z-1.4)/0.05;
else if(z<=1.5) adjust2=0.947207871338+(-0.00416554372005)*(z-1.45)/0.05;
else if(z<=1.55) adjust2=0.943042327618+(0.000431927458108)*(z-1.5)/0.05;
else if(z<=1.6) adjust2=0.943474255076+(0.0051043525604)*(z-1.55)/0.05;
else adjust2=0.948578607637;
end
endfunction
analog function real adjust3;
input z; real z;
begin
if(z<=0.2) adjust3=1.12873060399;
else if(z<=0.25) adjust3=1.12873060399+(-0.00964531374643)*(z-0.2)/0.05;
else if(z<=0.3) adjust3=1.11908529025+(-0.0164126200109)*(z-0.25)/0.05;
else if(z<=0.35) adjust3=1.10267267024+(-0.0198518460751)*(z-0.3)/0.05;
else if(z<=0.4) adjust3=1.08282082416+(-0.0198467692932)*(z-0.35)/0.05;
else if(z<=0.45) adjust3=1.06297405487+(-0.0173803404946)*(z-0.4)/0.05;
else if(z<=0.5) adjust3=1.04559371437+(-0.0141361089588)*(z-0.45)/0.05;
else if(z<=0.55) adjust3=1.03145760542+(-0.0118034821238)*(z-0.5)/0.05;
else if(z<=0.6) adjust3=1.01965412329+(-0.0112567888332)*(z-0.55)/0.05;
else if(z<=0.65) adjust3=1.00839733446+(-0.0119936559244)*(z-0.6)/0.05;
else if(z<=0.7) adjust3=0.996403678534+(-0.0123423515453)*(z-0.65)/0.05;
else if(z<=0.75) adjust3=0.984061326988+(-0.0105555448889)*(z-0.7)/0.05;
else if(z<=0.8) adjust3=0.973505782099+(-0.00611957803954)*(z-0.75)/0.05;
else if(z<=0.85) adjust3=0.96738620406+(-0.000287408396472)*(z-0.8)/0.05;
else if(z<=0.9) adjust3=0.967098795663+(0.0045833781713)*(z-0.85)/0.05;
else if(z<=0.95) adjust3=0.971682173835+(0.00647010898441)*(z-0.9)/0.05;
else if(z<=1) adjust3=0.978152282819+(0.00499008465003)*(z-0.95)/0.05;
else if(z<=1.05) adjust3=0.983142367469+(0.00162151080896)*(z-1)/0.05;
else if(z<=1.1) adjust3=0.984763878278+(-0.00144011389138)*(z-1.05)/0.05;
else if(z<=1.15) adjust3=0.983323764387+(-0.00288482557691)*(z-1.1)/0.05;
else if(z<=1.2) adjust3=0.98043893881+(-0.00299174108899)*(z-1.15)/0.05;
else if(z<=1.25) adjust3=0.977447197721+(-0.00298354340007)*(z-1.2)/0.05;
else if(z<=1.3) adjust3=0.974463654321+(-0.0037689244342)*(z-1.25)/0.05;
else if(z<=1.35) adjust3=0.970694729887+(-0.00514589543368)*(z-1.3)/0.05;
else if(z<=1.4) adjust3=0.965548834453+(-0.00601147279937)*(z-1.35)/0.05;
else if(z<=1.45) adjust3=0.959537361653+(-0.00527553239611)*(z-1.4)/0.05;
else if(z<=1.5) adjust3=0.954261829257+(-0.00267203242256)*(z-1.45)/0.05;
else if(z<=1.55) adjust3=0.951589796835+(0.00110000369635)*(z-1.5)/0.05;
else if(z<=1.6) adjust3=0.952689800531+(0.00484038476322)*(z-1.55)/0.05;
else adjust3=0.957530185294;
end
endfunction
analog function real adjust4;
input z; real z;
begin
if(z<=0.2) adjust4=1.1106240617;
else if(z<=0.25) adjust4=1.1106240617+(-0.00619920936031)*(z-0.2)/0.05;
else if(z<=0.3) adjust4=1.10442485234+(-0.0138859532877)*(z-0.25)/0.05;
else if(z<=0.35) adjust4=1.09053889905+(-0.0194240198365)*(z-0.3)/0.05;
else if(z<=0.4) adjust4=1.07111487922+(-0.0216350490341)*(z-0.35)/0.05;
else if(z<=0.45) adjust4=1.04947983018+(-0.0203329434823)*(z-0.4)/0.05;
else if(z<=0.5) adjust4=1.0291468867+(-0.0165273319551)*(z-0.45)/0.05;
else if(z<=0.55) adjust4=1.01261955475+(-0.0120520805597)*(z-0.5)/0.05;
else if(z<=0.6) adjust4=1.00056747419+(-0.00867496572151)*(z-0.55)/0.05;
else if(z<=0.65) adjust4=0.991892508464+(-0.00710705735198)*(z-0.6)/0.05;
else if(z<=0.7) adjust4=0.984785451112+(-0.00657982716466)*(z-0.65)/0.05;
else if(z<=0.75) adjust4=0.978205623948+(-0.00546952001103)*(z-0.7)/0.05;
else if(z<=0.8) adjust4=0.972736103937+(-0.0026510535484)*(z-0.75)/0.05;
else if(z<=0.85) adjust4=0.970085050388+(0.00148091324964)*(z-0.8)/0.05;
else if(z<=0.9) adjust4=0.971565963638+(0.00517360683524)*(z-0.85)/0.05;
else if(z<=0.95) adjust4=0.976739570473+(0.006546964684)*(z-0.9)/0.05;
else if(z<=1) adjust4=0.983286535157+(0.0049812632198)*(z-0.95)/0.05;
else if(z<=1.05) adjust4=0.988267798377+(0.00159040735827)*(z-1)/0.05;
else if(z<=1.1) adjust4=0.989858205735+(-0.0016506884238)*(z-1.05)/0.05;
else if(z<=1.15) adjust4=0.988207517311+(-0.00338575479403)*(z-1.1)/0.05;
else if(z<=1.2) adjust4=0.984821762517+(-0.00366543179679)*(z-1.15)/0.05;
else if(z<=1.25) adjust4=0.981156330721+(-0.00349539133325)*(z-1.2)/0.05;
else if(z<=1.3) adjust4=0.977660939387+(-0.00374287678585)*(z-1.25)/0.05;
else if(z<=1.35) adjust4=0.973918062602+(-0.00438876076837)*(z-1.3)/0.05;
else if(z<=1.4) adjust4=0.969529301833+(-0.00464579240077)*(z-1.35)/0.05;
else if(z<=1.45) adjust4=0.964883509432+(-0.00369784587188)*(z-1.4)/0.05;
else if(z<=1.5) adjust4=0.961185663561+(-0.0013741099251)*(z-1.45)/0.05;
else if(z<=1.55) adjust4=0.959811553635+(0.00172984835379)*(z-1.5)/0.05;
else if(z<=1.6) adjust4=0.961541401989+(0.00464045375282)*(z-1.55)/0.05;
else adjust4=0.966181855742;
end
endfunction
analog function real adjust5;
input z; real z;
begin
if(z<=0.2) adjust5=1.0960662459;
else if(z<=0.25) adjust5=1.0960662459+(-0.00236021014295)*(z-0.2)/0.05;
else if(z<=0.3) adjust5=1.09370603575+(-0.0111731833051)*(z-0.25)/0.05;
else if(z<=0.35) adjust5=1.08253285245+(-0.0190777206112)*(z-0.3)/0.05;
else if(z<=0.4) adjust5=1.06345513184+(-0.0238491093242)*(z-0.35)/0.05;
else if(z<=0.45) adjust5=1.03960602251+(-0.0241614780598)*(z-0.4)/0.05;
else if(z<=0.5) adjust5=1.01544454445+(-0.020379622507)*(z-0.45)/0.05;
else if(z<=0.55) adjust5=0.995064921948+(-0.0144236045225)*(z-0.5)/0.05;
else if(z<=0.6) adjust5=0.980641317425+(-0.00873584973899)*(z-0.55)/0.05;
else if(z<=0.65) adjust5=0.971905467686+(-0.00494780127939)*(z-0.6)/0.05;
else if(z<=0.7) adjust5=0.966957666407+(-0.00305202457425)*(z-0.65)/0.05;
else if(z<=0.75) adjust5=0.963905641833+(-0.00170131789529)*(z-0.7)/0.05;
else if(z<=0.8) adjust5=0.962204323937+(0.000489438015214)*(z-0.75)/0.05;
else if(z<=0.85) adjust5=0.962693761953+(0.00366921653979)*(z-0.8)/0.05;
else if(z<=0.9) adjust5=0.966362978492+(0.00657682936825)*(z-0.85)/0.05;
else if(z<=0.95) adjust5=0.972939807861+(0.00757520406912)*(z-0.9)/0.05;
else if(z<=1) adjust5=0.98051501193+(0.00601545898111)*(z-0.95)/0.05;
else if(z<=1.05) adjust5=0.986530470911+(0.00280015472769)*(z-1)/0.05;
else if(z<=1.1) adjust5=0.989330625638+(-0.00033964312458)*(z-1.05)/0.05;
else if(z<=1.15) adjust5=0.988990982514+(-0.00218414516638)*(z-1.1)/0.05;
else if(z<=1.2) adjust5=0.986806837347+(-0.00275784540182)*(z-1.15)/0.05;
else if(z<=1.25) adjust5=0.984048991946+(-0.00292314086135)*(z-1.2)/0.05;
else if(z<=1.3) adjust5=0.981125851084+(-0.00338926906862)*(z-1.25)/0.05;
else if(z<=1.35) adjust5=0.977736582016+(-0.00406448576374)*(z-1.3)/0.05;
else if(z<=1.4) adjust5=0.973672096252+(-0.00421730508745)*(z-1.35)/0.05;
else if(z<=1.45) adjust5=0.969454791165+(-0.00317414645936)*(z-1.4)/0.05;
else if(z<=1.5) adjust5=0.966280644705+(-0.000899382963879)*(z-1.45)/0.05;
else if(z<=1.55) adjust5=0.965381261741+(0.00196130422103)*(z-1.5)/0.05;
else if(z<=1.6) adjust5=0.967342565962+(0.00448726822854)*(z-1.55)/0.05;
else adjust5=0.971829834191;
end
endfunction
analog function real adjust6;
input z; real z;
begin
if(z<=0.2) adjust6=1.0860559867;
else if(z<=0.25) adjust6=1.0860559867+(0.000964937979137)*(z-0.2)/0.05;
else if(z<=0.3) adjust6=1.08702092468+(-0.00886289870457)*(z-0.25)/0.05;
else if(z<=0.35) adjust6=1.07815802597+(-0.0187776104482)*(z-0.3)/0.05;
else if(z<=0.4) adjust6=1.05938041552+(-0.0257930081849)*(z-0.35)/0.05;
else if(z<=0.45) adjust6=1.03358740734+(-0.027803744295)*(z-0.4)/0.05;
else if(z<=0.5) adjust6=1.00578366304+(-0.0247592261352)*(z-0.45)/0.05;
else if(z<=0.55) adjust6=0.981024436909+(-0.0185736833291)*(z-0.5)/0.05;
else if(z<=0.6) adjust6=0.96245075358+(-0.0118922869874)*(z-0.55)/0.05;
else if(z<=0.65) adjust6=0.950558466593+(-0.00658358688603)*(z-0.6)/0.05;
else if(z<=0.7) adjust6=0.943974879707+(-0.00289176334756)*(z-0.65)/0.05;
else if(z<=0.75) adjust6=0.941083116359+(0.000213213391278)*(z-0.7)/0.05;
else if(z<=0.8) adjust6=0.94129632975+(0.00374952240339)*(z-0.75)/0.05;
else if(z<=0.85) adjust6=0.945045852154+(0.007566394175)*(z-0.8)/0.05;
else if(z<=0.9) adjust6=0.952612246329+(0.0103140558668)*(z-0.85)/0.05;
else if(z<=0.95) adjust6=0.962926302196+(0.0105606190421)*(z-0.9)/0.05;
else if(z<=1) adjust6=0.973486921238+(0.00810293334411)*(z-0.95)/0.05;
else if(z<=1.05) adjust6=0.981589854582+(0.00430189312974)*(z-1)/0.05;
else if(z<=1.1) adjust6=0.985891747712+(0.00107222702879)*(z-1.05)/0.05;
else if(z<=1.15) adjust6=0.98696397474+(-0.00055973682372)*(z-1.1)/0.05;
else if(z<=1.2) adjust6=0.986404237917+(-0.00100932100326)*(z-1.15)/0.05;
else if(z<=1.25) adjust6=0.985394916913+(-0.00143115102932)*(z-1.2)/0.05;
else if(z<=1.3) adjust6=0.983963765884+(-0.00254214872437)*(z-1.25)/0.05;
else if(z<=1.35) adjust6=0.98142161716+(-0.00400020812847)*(z-1.3)/0.05;
else if(z<=1.4) adjust6=0.977421409031+(-0.00475734241014)*(z-1.35)/0.05;
else if(z<=1.45) adjust6=0.972664066621+(-0.00396085835884)*(z-1.4)/0.05;
else if(z<=1.5) adjust6=0.968703208262+(-0.00160440730976)*(z-1.45)/0.05;
else if(z<=1.55) adjust6=0.967098800953+(0.00150342491088)*(z-1.5)/0.05;
else if(z<=1.6) adjust6=0.968602225863+(0.00426974756207)*(z-1.55)/0.05;
else adjust6=0.972871973425;
end
endfunction
analog function real adjust7;
input z; real z;
begin
if(z<=0.2) adjust7=1.08001901434;
else if(z<=0.25) adjust7=1.08001901434+(0.00283371004871)*(z-0.2)/0.05;
else if(z<=0.3) adjust7=1.08285272439+(-0.00753735127251)*(z-0.25)/0.05;
else if(z<=0.35) adjust7=1.07531537312+(-0.0184168054297)*(z-0.3)/0.05;
else if(z<=0.4) adjust7=1.05689856769+(-0.0266128698059)*(z-0.35)/0.05;
else if(z<=0.45) adjust7=1.03028569788+(-0.0299378684467)*(z-0.4)/0.05;
else if(z<=0.5) adjust7=1.00034782944+(-0.0283248485755)*(z-0.45)/0.05;
else if(z<=0.55) adjust7=0.972022980861+(-0.0234966906579)*(z-0.5)/0.05;
else if(z<=0.6) adjust7=0.948526290203+(-0.017556843741)*(z-0.55)/0.05;
else if(z<=0.65) adjust7=0.930969446462+(-0.0116298828585)*(z-0.6)/0.05;
else if(z<=0.7) adjust7=0.919339563604+(-0.00551737583354)*(z-0.65)/0.05;
else if(z<=0.75) adjust7=0.91382218777+(0.00143507761259)*(z-0.7)/0.05;
else if(z<=0.8) adjust7=0.915257265383+(0.00900781641924)*(z-0.75)/0.05;
else if(z<=0.85) adjust7=0.924265081802+(0.015484427069)*(z-0.8)/0.05;
else if(z<=0.9) adjust7=0.939749508871+(0.0184010296587)*(z-0.85)/0.05;
else if(z<=0.95) adjust7=0.95815053853+(0.0163151581862)*(z-0.9)/0.05;
else if(z<=1) adjust7=0.974465696716+(0.0102785572768)*(z-0.95)/0.05;
else if(z<=1.05) adjust7=0.984744253993+(0.00350854379227)*(z-1)/0.05;
else if(z<=1.1) adjust7=0.988252797785+(-0.000814377806865)*(z-1.05)/0.05;
else if(z<=1.15) adjust7=0.987438419978+(-0.00171402194641)*(z-1.1)/0.05;
else if(z<=1.2) adjust7=0.985724398032+(-0.000674237658318)*(z-1.15)/0.05;
else if(z<=1.25) adjust7=0.985050160373+(-6.82262491669e-05)*(z-1.2)/0.05;
else if(z<=1.3) adjust7=0.984981934124+(-0.00125285692716)*(z-1.25)/0.05;
else if(z<=1.35) adjust7=0.983729077197+(-0.00371404943732)*(z-1.3)/0.05;
else if(z<=1.4) adjust7=0.98001502776+(-0.00570425216803)*(z-1.35)/0.05;
else if(z<=1.45) adjust7=0.974310775592+(-0.00568540775978)*(z-1.4)/0.05;
else if(z<=1.5) adjust7=0.968625367832+(-0.00336819118088)*(z-1.45)/0.05;
else if(z<=1.55) adjust7=0.965257176651+(0.000294108776326)*(z-1.5)/0.05;
else if(z<=1.6) adjust7=0.965551285427+(0.00385128805708)*(z-1.55)/0.05;
else adjust7=0.969402573484;
end
endfunction
analog function real adjust8;
input z; real z;
begin
if(z<=0.2) adjust8=1.07647543293;
else if(z<=0.25) adjust8=1.07647543293+(0.00250851955969)*(z-0.2)/0.05;
else if(z<=0.3) adjust8=1.07898395249+(-0.00763953352409)*(z-0.25)/0.05;
else if(z<=0.35) adjust8=1.07134441896+(-0.0178885597311)*(z-0.3)/0.05;
else if(z<=0.4) adjust8=1.05345585923+(-0.0255785429893)*(z-0.35)/0.05;
else if(z<=0.45) adjust8=1.02787731624+(-0.0293709257959)*(z-0.4)/0.05;
else if(z<=0.5) adjust8=0.998506390448+(-0.0297039372324)*(z-0.45)/0.05;
else if(z<=0.55) adjust8=0.968802453215+(-0.0278392431406)*(z-0.5)/0.05;
else if(z<=0.6) adjust8=0.940963210075+(-0.0243655040459)*(z-0.55)/0.05;
else if(z<=0.65) adjust8=0.916597706029+(-0.0185181546837)*(z-0.6)/0.05;
else if(z<=0.7) adjust8=0.898079551345+(-0.0090115606195)*(z-0.65)/0.05;
else if(z<=0.75) adjust8=0.889067990726+(0.00423096786071)*(z-0.7)/0.05;
else if(z<=0.8) adjust8=0.893298958586+(0.018815347431)*(z-0.75)/0.05;
else if(z<=0.85) adjust8=0.912114306017+(0.0300541046434)*(z-0.8)/0.05;
else if(z<=0.9) adjust8=0.942168410661+(0.0329105298803)*(z-0.85)/0.05;
else if(z<=0.95) adjust8=0.975078940541+(0.0253327233282)*(z-0.9)/0.05;
else if(z<=1) adjust8=1.00041166387+(0.0107848193425)*(z-0.95)/0.05;
else if(z<=1.05) adjust8=1.01119648321+(-0.00324071568528)*(z-1)/0.05;
else if(z<=1.1) adjust8=1.00795576753+(-0.0104289058742)*(z-1.05)/0.05;
else if(z<=1.15) adjust8=0.997526861652+(-0.00968832833488)*(z-1.1)/0.05;
else if(z<=1.2) adjust8=0.987838533317+(-0.00467436704716)*(z-1.15)/0.05;
else if(z<=1.25) adjust8=0.98316416627+(-0.000362449881184)*(z-1.2)/0.05;
else if(z<=1.3) adjust8=0.982801716389+(0.000224472447594)*(z-1.25)/0.05;
else if(z<=1.35) adjust8=0.983026188837+(-0.00260394344129)*(z-1.3)/0.05;
else if(z<=1.4) adjust8=0.980422245395+(-0.00611752226213)*(z-1.35)/0.05;
else if(z<=1.45) adjust8=0.974304723133+(-0.00747804422451)*(z-1.4)/0.05;
else if(z<=1.5) adjust8=0.966826678909+(-0.0056070762444)*(z-1.45)/0.05;
else if(z<=1.55) adjust8=0.961219602664+(-0.00142016002017)*(z-1.5)/0.05;
else if(z<=1.6) adjust8=0.959799442644+(0.00319215200951)*(z-1.55)/0.05;
else adjust8=0.962991594654;
end
endfunction
analog function real adjust9;
input z; real z;
begin
if(z<=0.2) adjust9=1.0738363832;
else if(z<=0.25) adjust9=1.0738363832+(-0.000286220286837)*(z-0.2)/0.05;
else if(z<=0.3) adjust9=1.07355016291+(-0.00931127311781)*(z-0.25)/0.05;
else if(z<=0.35) adjust9=1.06423888979+(-0.0171342632191)*(z-0.3)/0.05;
else if(z<=0.4) adjust9=1.04710462658+(-0.0223623143905)*(z-0.35)/0.05;
else if(z<=0.45) adjust9=1.02474231218+(-0.0254464419409)*(z-0.4)/0.05;
else if(z<=0.5) adjust9=0.999295870244+(-0.0279068013175)*(z-0.45)/0.05;
else if(z<=0.55) adjust9=0.971389068926+(-0.0303031110982)*(z-0.5)/0.05;
else if(z<=0.6) adjust9=0.941085957828+(-0.0306753556639)*(z-0.55)/0.05;
else if(z<=0.65) adjust9=0.910410602164+(-0.0252314462477)*(z-0.6)/0.05;
else if(z<=0.7) adjust9=0.885179155917+(-0.0111438828615)*(z-0.65)/0.05;
else if(z<=0.75) adjust9=0.874035273055+(0.010799541113)*(z-0.7)/0.05;
else if(z<=0.8) adjust9=0.884834814168+(0.0353421601364)*(z-0.75)/0.05;
else if(z<=0.85) adjust9=0.920176974305+(0.0535289832217)*(z-0.8)/0.05;
else if(z<=0.9) adjust9=0.973705957526+(0.0556585242114)*(z-0.85)/0.05;
else if(z<=0.95) adjust9=1.02936448174+(0.0376864461958)*(z-0.9)/0.05;
else if(z<=1) adjust9=1.06705092793+(0.00716096406121)*(z-0.95)/0.05;
else if(z<=1.05) adjust9=1.07421189199+(-0.0200836222559)*(z-1)/0.05;
else if(z<=1.1) adjust9=1.05412826974+(-0.0319138523944)*(z-1.05)/0.05;
else if(z<=1.15) adjust9=1.02221441734+(-0.0276312660198)*(z-1.1)/0.05;
else if(z<=1.2) adjust9=0.994583151325+(-0.0150646124184)*(z-1.15)/0.05;
else if(z<=1.25) adjust9=0.979518538906+(-0.0034373923038)*(z-1.2)/0.05;
else if(z<=1.3) adjust9=0.976081146602+(0.00160856410108)*(z-1.25)/0.05;
else if(z<=1.35) adjust9=0.977689710703+(-0.000239097674428)*(z-1.3)/0.05;
else if(z<=1.4) adjust9=0.977450613029+(-0.00512844137724)*(z-1.35)/0.05;
else if(z<=1.45) adjust9=0.972322171652+(-0.00836036459563)*(z-1.4)/0.05;
else if(z<=1.5) adjust9=0.963961807056+(-0.00749447162794)*(z-1.45)/0.05;
else if(z<=1.55) adjust9=0.956467335428+(-0.00311693150873)*(z-1.5)/0.05;
else if(z<=1.6) adjust9=0.953350403919+(0.00246404332769)*(z-1.55)/0.05;
else adjust9=0.955814447247;
end
endfunction
analog function real adjust10;
input z; real z;
begin
if(z<=0.2) adjust10=1.07100566936;
else if(z<=0.25) adjust10=1.07100566936+(-0.00520413605972)*(z-0.2)/0.05;
else if(z<=0.3) adjust10=1.0658015333+(-0.0122833610004)*(z-0.25)/0.05;
else if(z<=0.35) adjust10=1.0535181723+(-0.0161459375539)*(z-0.3)/0.05;
else if(z<=0.4) adjust10=1.03737223475+(-0.0171871226042)*(z-0.35)/0.05;
else if(z<=0.45) adjust10=1.02018511214+(-0.0183167218665)*(z-0.4)/0.05;
else if(z<=0.5) adjust10=1.00186839028+(-0.0226580160447)*(z-0.45)/0.05;
else if(z<=0.55) adjust10=0.979210374232+(-0.0300066317762)*(z-0.5)/0.05;
else if(z<=0.6) adjust10=0.949203742456+(-0.0350371144955)*(z-0.55)/0.05;
else if(z<=0.65) adjust10=0.91416662796+(-0.0300077934484)*(z-0.6)/0.05;
else if(z<=0.7) adjust10=0.884158834512+(-0.0102837004875)*(z-0.65)/0.05;
else if(z<=0.75) adjust10=0.873875134024+(0.0223273420484)*(z-0.7)/0.05;
else if(z<=0.8) adjust10=0.896202476073+(0.0595185508423)*(z-0.75)/0.05;
else if(z<=0.85) adjust10=0.955721026915+(0.0869593906986)*(z-0.8)/0.05;
else if(z<=0.9) adjust10=1.04268041761+(0.0873422155856)*(z-0.85)/0.05;
else if(z<=0.95) adjust10=1.1300226332+(0.0522592268406)*(z-0.9)/0.05;
else if(z<=1) adjust10=1.18228186004+(-0.00396863395391)*(z-0.95)/0.05;
else if(z<=1.05) adjust10=1.17831322609+(-0.0508049826642)*(z-1)/0.05;
else if(z<=1.1) adjust10=1.12750824342+(-0.0673882775953)*(z-1.05)/0.05;
else if(z<=1.15) adjust10=1.06011996583+(-0.0558279633088)*(z-1.1)/0.05;
else if(z<=1.2) adjust10=1.00429200252+(-0.0314280371055)*(z-1.15)/0.05;
else if(z<=1.25) adjust10=0.972863965412+(-0.00905972034293)*(z-1.2)/0.05;
else if(z<=1.3) adjust10=0.963804245069+(0.00286110808167)*(z-1.25)/0.05;
else if(z<=1.35) adjust10=0.966665353151+(0.00340533669316)*(z-1.3)/0.05;
else if(z<=1.4) adjust10=0.970070689844+(-0.0023954434634)*(z-1.35)/0.05;
else if(z<=1.45) adjust10=0.967675246381+(-0.00768122011334)*(z-1.4)/0.05;
else if(z<=1.5) adjust10=0.959994026267+(-0.00825309965455)*(z-1.45)/0.05;
else if(z<=1.55) adjust10=0.951740926613+(-0.00411501972858)*(z-1.5)/0.05;
else if(z<=1.6) adjust10=0.947625906884+(0.00208771434194)*(z-1.55)/0.05;
else adjust10=0.949713621226;
end
endfunction
analog function real adjust11;
input z; real z;
begin
if(z<=0.2) adjust11=1.06757879365;
else if(z<=0.25) adjust11=1.06757879365+(-0.0113186765803)*(z-0.2)/0.05;
else if(z<=0.3) adjust11=1.05626011707+(-0.0159006019781)*(z-0.25)/0.05;
else if(z<=0.35) adjust11=1.04035951509+(-0.0149304157898)*(z-0.3)/0.05;
else if(z<=0.4) adjust11=1.0254290993+(-0.0107584246045)*(z-0.35)/0.05;
else if(z<=0.45) adjust11=1.0146706747+(-0.00894673610735)*(z-0.4)/0.05;
else if(z<=0.5) adjust11=1.00572393859+(-0.0145327312342)*(z-0.45)/0.05;
else if(z<=0.55) adjust11=0.991191207359+(-0.0267203240804)*(z-0.5)/0.05;
else if(z<=0.6) adjust11=0.964470883278+(-0.0365035930824)*(z-0.55)/0.05;
else if(z<=0.65) adjust11=0.927967290196+(-0.0317295255452)*(z-0.6)/0.05;
else if(z<=0.7) adjust11=0.896237764651+(-0.00584012818774)*(z-0.65)/0.05;
else if(z<=0.75) adjust11=0.890397636463+(0.0384464215834)*(z-0.7)/0.05;
else if(z<=0.8) adjust11=0.928844058046+(0.0900319998772)*(z-0.75)/0.05;
else if(z<=0.85) adjust11=1.01887605792+(0.128275265701)*(z-0.8)/0.05;
else if(z<=0.9) adjust11=1.14715132362+(0.124939328193)*(z-0.85)/0.05;
else if(z<=0.95) adjust11=1.27209065182+(0.0279093481819)*(z-0.9)/0.05;
else if(z<=1) adjust11=1.3+(0)*(z-0.95)/0.05;
else if(z<=1.05) adjust11=1.3+(-0.0857489653203)*(z-1)/0.05;
else if(z<=1.1) adjust11=1.21425103468+(-0.113926941955)*(z-1.05)/0.05;
else if(z<=1.15) adjust11=1.10032409273+(-0.0896764015311)*(z-1.1)/0.05;
else if(z<=1.2) adjust11=1.01064769119+(-0.0498873215021)*(z-1.15)/0.05;
else if(z<=1.25) adjust11=0.960760369692+(-0.0151745916164)*(z-1.2)/0.05;
else if(z<=1.3) adjust11=0.945585778075+(0.00439531225097)*(z-1.25)/0.05;
else if(z<=1.35) adjust11=0.949981090326+(0.00792974015522)*(z-1.3)/0.05;
else if(z<=1.4) adjust11=0.957910830482+(0.00169879302961)*(z-1.35)/0.05;
else if(z<=1.45) adjust11=0.959609623511+(-0.00537957016168)*(z-1.4)/0.05;
else if(z<=1.5) adjust11=0.95423005335+(-0.00739106293821)*(z-1.45)/0.05;
else if(z<=1.55) adjust11=0.946838990411+(-0.00374127876463)*(z-1.5)/0.05;
else if(z<=1.6) adjust11=0.943097711647+(0.00264847612341)*(z-1.55)/0.05;
else adjust11=0.94574618777;
end
endfunction
analog function real adjust12;
input z; real z;
begin
if(z<=0.2) adjust12=1.06363750693;
else if(z<=0.25) adjust12=1.06363750693+(-0.0173703798298)*(z-0.2)/0.05;
else if(z<=0.3) adjust12=1.0462671271+(-0.0192885842077)*(z-0.25)/0.05;
else if(z<=0.35) adjust12=1.02697854289+(-0.0134661673713)*(z-0.3)/0.05;
else if(z<=0.4) adjust12=1.01351237552+(-0.00401584508468)*(z-0.35)/0.05;
else if(z<=0.45) adjust12=1.00949653043+(0.00116020215739)*(z-0.4)/0.05;
else if(z<=0.5) adjust12=1.01065673259+(-0.00484444896014)*(z-0.45)/0.05;
else if(z<=0.55) adjust12=1.00581228363+(-0.0209386405942)*(z-0.5)/0.05;
else if(z<=0.6) adjust12=0.984873643035+(-0.0347760140234)*(z-0.55)/0.05;
else if(z<=0.65) adjust12=0.950097629012+(-0.0300344605246)*(z-0.6)/0.05;
else if(z<=0.7) adjust12=0.920063168487+(0.00165797857782)*(z-0.65)/0.05;
else if(z<=0.75) adjust12=0.921721147065+(0.0568820977037)*(z-0.7)/0.05;
else if(z<=0.8) adjust12=0.978603244769+(0.121992971178)*(z-0.75)/0.05;
else if(z<=0.85) adjust12=1.10059621595+(0.169314733322)*(z-0.8)/0.05;
else if(z<=0.9) adjust12=1.26991094927+(0.0300890507315)*(z-0.85)/0.05;
else if(z<=0.95) adjust12=1.3+(0)*(z-0.9)/0.05;
else if(z<=1) adjust12=1.3+(0)*(z-0.95)/0.05;
else if(z<=1.05) adjust12=1.3+(-0.0169448378018)*(z-1)/0.05;
else if(z<=1.1) adjust12=1.2830551622+(-0.160236506065)*(z-1.05)/0.05;
else if(z<=1.15) adjust12=1.12281865613+(-0.118903334732)*(z-1.1)/0.05;
else if(z<=1.2) adjust12=1.0039153214+(-0.0635845968329)*(z-1.15)/0.05;
else if(z<=1.25) adjust12=0.940330724569+(-0.018361805761)*(z-1.2)/0.05;
else if(z<=1.3) adjust12=0.921968918808+(0.00705666025457)*(z-1.25)/0.05;
else if(z<=1.35) adjust12=0.929025579062+(0.0127397634481)*(z-1.3)/0.05;
else if(z<=1.4) adjust12=0.94176534251+(0.00624079820018)*(z-1.35)/0.05;
else if(z<=1.45) adjust12=0.948006140711+(-0.0019548555813)*(z-1.4)/0.05;
else if(z<=1.5) adjust12=0.946051285129+(-0.00482118677679)*(z-1.45)/0.05;
else if(z<=1.55) adjust12=0.941230098352+(-0.00153066172346)*(z-1.5)/0.05;
else if(z<=1.6) adjust12=0.939699436629+(0.00468398319233)*(z-1.55)/0.05;
else adjust12=0.944383419821;
end
endfunction
analog function real adjust13;
input z; real z;
begin
if(z<=0.2) adjust13=1.05933463044;
else if(z<=0.25) adjust13=1.05933463044+(-0.0221140415174)*(z-0.2)/0.05;
else if(z<=0.3) adjust13=1.03722058893+(-0.0215842638063)*(z-0.25)/0.05;
else if(z<=0.35) adjust13=1.01563632512+(-0.0116823552706)*(z-0.3)/0.05;
else if(z<=0.4) adjust13=1.00395396985+(0.00216102951767)*(z-0.35)/0.05;
else if(z<=0.45) adjust13=1.00611499937+(0.0103876679986)*(z-0.4)/0.05;
else if(z<=0.5) adjust13=1.01650266737+(0.00468142475506)*(z-0.45)/0.05;
else if(z<=0.55) adjust13=1.02118409212+(-0.0137785153029)*(z-0.5)/0.05;
else if(z<=0.6) adjust13=1.00740557682+(-0.030235521266)*(z-0.55)/0.05;
else if(z<=0.65) adjust13=0.977170055553+(-0.02528962285)*(z-0.6)/0.05;
else if(z<=0.7) adjust13=0.951880432703+(0.0106956130199)*(z-0.65)/0.05;
else if(z<=0.75) adjust13=0.962576045723+(0.073493331437)*(z-0.7)/0.05;
else if(z<=0.8) adjust13=1.03606937716+(0.146560180553)*(z-0.75)/0.05;
else if(z<=0.85) adjust13=1.18262955771+(0.117370442287)*(z-0.8)/0.05;
else if(z<=0.9) adjust13=1.3+(0)*(z-0.85)/0.05;
else if(z<=0.95) adjust13=1.3+(0)*(z-0.9)/0.05;
else if(z<=1) adjust13=1.3+(0)*(z-0.95)/0.05;
else if(z<=1.05) adjust13=1.3+(-0.00568556432974)*(z-1)/0.05;
else if(z<=1.1) adjust13=1.29431443567+(-0.18828254052)*(z-1.05)/0.05;
else if(z<=1.15) adjust13=1.10603189515+(-0.130790358813)*(z-1.1)/0.05;
else if(z<=1.2) adjust13=0.975241536337+(-0.0653195481934)*(z-1.15)/0.05;
else if(z<=1.25) adjust13=0.909921988144+(-0.0152192766178)*(z-1.2)/0.05;
else if(z<=1.3) adjust13=0.894702711526+(0.0118171332799)*(z-1.25)/0.05;
else if(z<=1.35) adjust13=0.906519844806+(0.017370983851)*(z-1.3)/0.05;
else if(z<=1.4) adjust13=0.923890828657+(0.0102571029037)*(z-1.35)/0.05;
else if(z<=1.45) adjust13=0.934147931561+(0.00181656258882)*(z-1.4)/0.05;
else if(z<=1.5) adjust13=0.93596449415+(-0.000856770285892)*(z-1.45)/0.05;
else if(z<=1.55) adjust13=0.935107723864+(0.00257473346431)*(z-1.5)/0.05;
else if(z<=1.6) adjust13=0.937682457328+(0.00840089596882)*(z-1.55)/0.05;
else adjust13=0.946083353297;
end
endfunction
analog function real adjust14;
input z; real z;
begin
if(z<=0.2) adjust14=1.05453972243;
else if(z<=0.25) adjust14=1.05453972243+(-0.0246314247099)*(z-0.2)/0.05;
else if(z<=0.3) adjust14=1.02990829772+(-0.0221363284433)*(z-0.25)/0.05;
else if(z<=0.35) adjust14=1.00777196927+(-0.00946897827813)*(z-0.3)/0.05;
else if(z<=0.4) adjust14=0.998302990997+(0.00716854772787)*(z-0.35)/0.05;
else if(z<=0.45) adjust14=1.00547153872+(0.0174161070817)*(z-0.4)/0.05;
else if(z<=0.5) adjust14=1.02288764581+(0.0123497890707)*(z-0.45)/0.05;
else if(z<=0.55) adjust14=1.03523743488+(-0.00671473779784)*(z-0.5)/0.05;
else if(z<=0.6) adjust14=1.02852269708+(-0.0238691400414)*(z-0.55)/0.05;
else if(z<=0.65) adjust14=1.00465355704+(-0.0184835386662)*(z-0.6)/0.05;
else if(z<=0.7) adjust14=0.986170018372+(0.0191735512378)*(z-0.65)/0.05;
else if(z<=0.75) adjust14=1.00534356961+(0.0833609879235)*(z-0.7)/0.05;
else if(z<=0.8) adjust14=1.08870455753+(0.153753894067)*(z-0.75)/0.05;
else if(z<=0.85) adjust14=1.2424584516+(0.0575415484001)*(z-0.8)/0.05;
else if(z<=0.9) adjust14=1.3+(0)*(z-0.85)/0.05;
else if(z<=0.95) adjust14=1.3+(0)*(z-0.9)/0.05;
else if(z<=1) adjust14=1.3+(0)*(z-0.95)/0.05;
else if(z<=1.05) adjust14=1.3+(-0.075593782681)*(z-1)/0.05;
else if(z<=1.1) adjust14=1.22440621732+(-0.184092522572)*(z-1.05)/0.05;
else if(z<=1.15) adjust14=1.04031369475+(-0.117832198789)*(z-1.1)/0.05;
else if(z<=1.2) adjust14=0.922481495958+(-0.0515142094467)*(z-1.15)/0.05;
else if(z<=1.25) adjust14=0.870967286511+(-0.00404043307401)*(z-1.2)/0.05;
else if(z<=1.3) adjust14=0.866926853437+(0.0193023599534)*(z-1.25)/0.05;
else if(z<=1.35) adjust14=0.886229213391+(0.02166991674)*(z-1.3)/0.05;
else if(z<=1.4) adjust14=0.907899130131+(0.0131491745728)*(z-1.35)/0.05;
else if(z<=1.45) adjust14=0.921048304703+(0.00522881476002)*(z-1.4)/0.05;
else if(z<=1.5) adjust14=0.926277119463+(0.00388794497174)*(z-1.45)/0.05;
else if(z<=1.55) adjust14=0.930165064435+(0.00810633897053)*(z-1.5)/0.05;
else if(z<=1.6) adjust14=0.938271403406+(0.013444365272)*(z-1.55)/0.05;
else adjust14=0.951715768678;
end
endfunction
analog function real adjust15;
input z; real z;
begin
if(z<=0.2) adjust15=1.04874385791;
else if(z<=0.25) adjust15=1.04874385791+(-0.0245227750124)*(z-0.2)/0.05;
else if(z<=0.3) adjust15=1.0242210829+(-0.020627565642)*(z-0.25)/0.05;
else if(z<=0.35) adjust15=1.00359351725+(-0.00670946397233)*(z-0.3)/0.05;
else if(z<=0.4) adjust15=0.996884053282+(0.0107750408357)*(z-0.35)/0.05;
else if(z<=0.45) adjust15=1.00765909412+(0.0215113887381)*(z-0.4)/0.05;
else if(z<=0.5) adjust15=1.02917048286+(0.0169352692619)*(z-0.45)/0.05;
else if(z<=0.55) adjust15=1.04610575212+(-0.00119281034885)*(z-0.5)/0.05;
else if(z<=0.6) adjust15=1.04491294177+(-0.0170583132586)*(z-0.55)/0.05;
else if(z<=0.65) adjust15=1.02785462851+(-0.0110049958178)*(z-0.6)/0.05;
else if(z<=0.7) adjust15=1.01684963269+(0.0251247651821)*(z-0.65)/0.05;
else if(z<=0.75) adjust15=1.04197439787+(0.0830243525444)*(z-0.7)/0.05;
else if(z<=0.8) adjust15=1.12499875042+(0.138334055044)*(z-0.75)/0.05;
else if(z<=0.85) adjust15=1.26333280546+(0.0366671945371)*(z-0.8)/0.05;
else if(z<=0.9) adjust15=1.3+(0)*(z-0.85)/0.05;
else if(z<=0.95) adjust15=1.3+(0)*(z-0.9)/0.05;
else if(z<=1) adjust15=1.3+(-0.0222272242871)*(z-0.95)/0.05;
else if(z<=1.05) adjust15=1.27777277571+(-0.191047035151)*(z-1)/0.05;
else if(z<=1.1) adjust15=1.08672574056+(-0.149622486604)*(z-1.05)/0.05;
else if(z<=1.15) adjust15=0.937103253959+(-0.083684760515)*(z-1.1)/0.05;
else if(z<=1.2) adjust15=0.853418493443+(-0.0245737278557)*(z-1.15)/0.05;
else if(z<=1.25) adjust15=0.828844765588+(0.0142617824279)*(z-1.2)/0.05;
else if(z<=1.3) adjust15=0.843106548016+(0.0293951609942)*(z-1.25)/0.05;
else if(z<=1.35) adjust15=0.87250170901+(0.0257009449824)*(z-1.3)/0.05;
else if(z<=1.4) adjust15=0.898202653992+(0.0148113772336)*(z-1.35)/0.05;
else if(z<=1.45) adjust15=0.913014031226+(0.00783503014237)*(z-1.4)/0.05;
else if(z<=1.5) adjust15=0.920849061368+(0.00863175530526)*(z-1.45)/0.05;
else if(z<=1.55) adjust15=0.929480816674+(0.0140990673863)*(z-1.5)/0.05;
else if(z<=1.6) adjust15=0.94357988406+(0.0188455529584)*(z-1.55)/0.05;
else adjust15=0.962425437018;
end
endfunction
analog function real adjust16;
input z; real z;
begin
if(z<=0.2) adjust16=1.04126163756;
else if(z<=0.25) adjust16=1.04126163756+(-0.0219490742491)*(z-0.2)/0.05;
else if(z<=0.3) adjust16=1.01931256331+(-0.0171166208745)*(z-0.25)/0.05;
else if(z<=0.35) adjust16=1.00219594243+(-0.00332354373489)*(z-0.3)/0.05;
else if(z<=0.4) adjust16=0.9988723987+(0.0131160702854)*(z-0.35)/0.05;
else if(z<=0.45) adjust16=1.01198846899+(0.0226533970162)*(z-0.4)/0.05;
else if(z<=0.5) adjust16=1.034641866+(0.0180009753557)*(z-0.45)/0.05;
else if(z<=0.55) adjust16=1.05264284136+(0.00178567358861)*(z-0.5)/0.05;
else if(z<=0.6) adjust16=1.05442851495+(-0.0112224506667)*(z-0.55)/0.05;
else if(z<=0.65) adjust16=1.04320606428+(-0.00429643744151)*(z-0.6)/0.05;
else if(z<=0.7) adjust16=1.03890962684+(0.0274839915953)*(z-0.65)/0.05;
else if(z<=0.75) adjust16=1.06639361843+(0.0725539858708)*(z-0.7)/0.05;
else if(z<=0.8) adjust16=1.1389476043+(0.104122822159)*(z-0.75)/0.05;
else if(z<=0.85) adjust16=1.24307042646+(0.056929573537)*(z-0.8)/0.05;
else if(z<=0.9) adjust16=1.3+(0)*(z-0.85)/0.05;
else if(z<=0.95) adjust16=1.3+(-0.0626002261356)*(z-0.9)/0.05;
else if(z<=1) adjust16=1.23739977386+(-0.160338802716)*(z-0.95)/0.05;
else if(z<=1.05) adjust16=1.07706097115+(-0.152491357689)*(z-1)/0.05;
else if(z<=1.1) adjust16=0.924569613459+(-0.100967286547)*(z-1.05)/0.05;
else if(z<=1.15) adjust16=0.823602326912+(-0.0403732166557)*(z-1.1)/0.05;
else if(z<=1.2) adjust16=0.783229110256+(0.00871981046368)*(z-1.15)/0.05;
else if(z<=1.25) adjust16=0.79194892072+(0.0366188698952)*(z-1.2)/0.05;
else if(z<=1.3) adjust16=0.828567790615+(0.0411130865192)*(z-1.25)/0.05;
else if(z<=1.35) adjust16=0.869680877134+(0.029457882432)*(z-1.3)/0.05;
else if(z<=1.4) adjust16=0.899138759566+(0.0154120666427)*(z-1.35)/0.05;
else if(z<=1.45) adjust16=0.914550826209+(0.00940040876349)*(z-1.4)/0.05;
else if(z<=1.5) adjust16=0.923951234972+(0.0125333771023)*(z-1.45)/0.05;
else if(z<=1.55) adjust16=0.936484612074+(0.0192606638191)*(z-1.5)/0.05;
else if(z<=1.6) adjust16=0.955745275893+(0.0231842392794)*(z-1.55)/0.05;
else adjust16=0.978929515173;
end
endfunction
analog function real adjust17;
input z; real z;
begin
if(z<=0.2) adjust17=1.03160689845;
else if(z<=0.25) adjust17=1.03160689845+(-0.0175327497258)*(z-0.2)/0.05;
else if(z<=0.3) adjust17=1.01407414873+(-0.012007752025)*(z-0.25)/0.05;
else if(z<=0.35) adjust17=1.0020663967+(0.000687996266086)*(z-0.3)/0.05;
else if(z<=0.4) adjust17=1.00275439297+(0.0146104784154)*(z-0.35)/0.05;
else if(z<=0.45) adjust17=1.01736487138+(0.0214882217723)*(z-0.4)/0.05;
else if(z<=0.5) adjust17=1.03885309316+(0.0159909377356)*(z-0.45)/0.05;
else if(z<=0.55) adjust17=1.05484403089+(0.00195787290931)*(z-0.5)/0.05;
else if(z<=0.6) adjust17=1.0568019038+(-0.00740422888721)*(z-0.55)/0.05;
else if(z<=0.65) adjust17=1.04939767491+(0.00053036783891)*(z-0.6)/0.05;
else if(z<=0.7) adjust17=1.04992804275+(0.0264267694345)*(z-0.65)/0.05;
else if(z<=0.75) adjust17=1.07635481219+(0.0556601728101)*(z-0.7)/0.05;
else if(z<=0.8) adjust17=1.132014985+(0.0621266301032)*(z-0.75)/0.05;
else if(z<=0.85) adjust17=1.1941416151+(0.0225155748173)*(z-0.8)/0.05;
else if(z<=0.9) adjust17=1.21665718992+(-0.0555586177103)*(z-0.85)/0.05;
else if(z<=0.95) adjust17=1.16109857221+(-0.125100140102)*(z-0.9)/0.05;
else if(z<=1) adjust17=1.03599843211+(-0.143153984223)*(z-0.95)/0.05;
else if(z<=1.05) adjust17=0.892844447884+(-0.110487120427)*(z-1)/0.05;
else if(z<=1.1) adjust17=0.782357327457+(-0.0547108469063)*(z-1.05)/0.05;
else if(z<=1.15) adjust17=0.727646480551+(0.000473598582804)*(z-1.1)/0.05;
else if(z<=1.2) adjust17=0.728120079134+(0.041308683182)*(z-1.15)/0.05;
else if(z<=1.25) adjust17=0.769428762316+(0.0591837648751)*(z-1.2)/0.05;
else if(z<=1.3) adjust17=0.828612527191+(0.0527622323282)*(z-1.25)/0.05;
else if(z<=1.35) adjust17=0.881374759519+(0.0325885034275)*(z-1.3)/0.05;
else if(z<=1.4) adjust17=0.913963262946+(0.0150718487758)*(z-1.35)/0.05;
else if(z<=1.45) adjust17=0.929035111722+(0.00974836427483)*(z-1.4)/0.05;
else if(z<=1.5) adjust17=0.938783475997+(0.0147714498786)*(z-1.45)/0.05;
else if(z<=1.55) adjust17=0.953554925876+(0.0222243486845)*(z-1.5)/0.05;
else if(z<=1.6) adjust17=0.97577927456+(0.0249233203503)*(z-1.55)/0.05;
else adjust17=1.00070259491;
end
endfunction
analog function real adjust18;
input z; real z;
begin
if(z<=0.2) adjust18=1.01982986038;
else if(z<=0.25) adjust18=1.01982986038+(-0.012153420562)*(z-0.2)/0.05;
else if(z<=0.3) adjust18=1.00767643981+(-0.00595590249433)*(z-0.25)/0.05;
else if(z<=0.35) adjust18=1.00172053732+(0.00520337097133)*(z-0.3)/0.05;
else if(z<=0.4) adjust18=1.00692390829+(0.0158043351037)*(z-0.35)/0.05;
else if(z<=0.45) adjust18=1.02272824339+(0.0191006674995)*(z-0.4)/0.05;
else if(z<=0.5) adjust18=1.04182891089+(0.0120467799651)*(z-0.45)/0.05;
else if(z<=0.55) adjust18=1.05387569086+(-0.000157771583374)*(z-0.5)/0.05;
else if(z<=0.6) adjust18=1.05371791928+(-0.00596838796167)*(z-0.55)/0.05;
else if(z<=0.65) adjust18=1.04774953131+(0.00296201200776)*(z-0.6)/0.05;
else if(z<=0.7) adjust18=1.05071154332+(0.0230417016069)*(z-0.65)/0.05;
else if(z<=0.75) adjust18=1.07375324493+(0.0375966444782)*(z-0.7)/0.05;
else if(z<=0.8) adjust18=1.11134988941+(0.0240614770528)*(z-0.75)/0.05;
else if(z<=0.85) adjust18=1.13541136646+(-0.0274478897474)*(z-0.8)/0.05;
else if(z<=0.9) adjust18=1.10796347671+(-0.0938825902784)*(z-0.85)/0.05;
else if(z<=0.95) adjust18=1.01408088643+(-0.132031824905)*(z-0.9)/0.05;
else if(z<=1) adjust18=0.882049061529+(-0.121124375984)*(z-0.95)/0.05;
else if(z<=1.05) adjust18=0.760924685545+(-0.0609246855451)*(z-1)/0.05;
else if(z<=1.1) adjust18=0.7+(0)*(z-1.05)/0.05;
else if(z<=1.15) adjust18=0.7+(0.000144014571118)*(z-1.1)/0.05;
else if(z<=1.2) adjust18=0.700144014571+(0.0686791493297)*(z-1.15)/0.05;
else if(z<=1.25) adjust18=0.768823163901+(0.0784697594491)*(z-1.2)/0.05;
else if(z<=1.3) adjust18=0.84729292335+(0.0622215769496)*(z-1.25)/0.05;
else if(z<=1.35) adjust18=0.9095145003+(0.0343296830701)*(z-1.3)/0.05;
else if(z<=1.4) adjust18=0.94384418337+(0.0137216884833)*(z-1.35)/0.05;
else if(z<=1.45) adjust18=0.957565871853+(0.00871522795866)*(z-1.4)/0.05;
else if(z<=1.5) adjust18=0.966281099812+(0.0146849954051)*(z-1.45)/0.05;
else if(z<=1.55) adjust18=0.980966095217+(0.0218804859514)*(z-1.5)/0.05;
else if(z<=1.6) adjust18=1.00284658117+(0.0228699866567)*(z-1.55)/0.05;
else adjust18=1.02571656782;
end
endfunction
analog function real adjust19;
input z; real z;
begin
if(z<=0.2) adjust19=1.00663318306;
else if(z<=0.25) adjust19=1.00663318306+(-0.00670777112455)*(z-0.2)/0.05;
else if(z<=0.3) adjust19=0.999925411935+(0.000273116596814)*(z-0.25)/0.05;
else if(z<=0.35) adjust19=1.00019852853+(0.00995473342361)*(z-0.3)/0.05;
else if(z<=0.4) adjust19=1.01015326196+(0.0171657243957)*(z-0.35)/0.05;
else if(z<=0.45) adjust19=1.02731898635+(0.0166559426667)*(z-0.4)/0.05;
else if(z<=0.5) adjust19=1.04397492902+(0.00760948309573)*(z-0.45)/0.05;
else if(z<=0.55) adjust19=1.05158441211+(-0.00349135479008)*(z-0.5)/0.05;
else if(z<=0.6) adjust19=1.04809305732+(-0.00655744187242)*(z-0.55)/0.05;
else if(z<=0.65) adjust19=1.04153561545+(0.00312722406997)*(z-0.6)/0.05;
else if(z<=0.7) adjust19=1.04466283952+(0.0186251196792)*(z-0.65)/0.05;
else if(z<=0.75) adjust19=1.0632879592+(0.022549319392)*(z-0.7)/0.05;
else if(z<=0.8) adjust19=1.08583727859+(-0.0029334326576)*(z-0.75)/0.05;
else if(z<=0.85) adjust19=1.08290384593+(-0.0569988056601)*(z-0.8)/0.05;
else if(z<=0.9) adjust19=1.02590504027+(-0.10975556949)*(z-0.85)/0.05;
else if(z<=0.95) adjust19=0.916149470785+(-0.126274456588)*(z-0.9)/0.05;
else if(z<=1) adjust19=0.789875014197+(-0.0898750141971)*(z-0.95)/0.05;
else if(z<=1.05) adjust19=0.7+(0)*(z-1)/0.05;
else if(z<=1.1) adjust19=0.7+(0)*(z-1.05)/0.05;
else if(z<=1.15) adjust19=0.7+(0.00551362601222)*(z-1.1)/0.05;
else if(z<=1.2) adjust19=0.705513626012+(0.0887355204437)*(z-1.15)/0.05;
else if(z<=1.25) adjust19=0.794249146456+(0.0916352259541)*(z-1.2)/0.05;
else if(z<=1.3) adjust19=0.88588437241+(0.0673048888146)*(z-1.25)/0.05;
else if(z<=1.35) adjust19=0.953189261225+(0.0337835582557)*(z-1.3)/0.05;
else if(z<=1.4) adjust19=0.98697281948+(0.011297400728)*(z-1.35)/0.05;
else if(z<=1.45) adjust19=0.998270220208+(0.00635283445998)*(z-1.4)/0.05;
else if(z<=1.5) adjust19=1.00462305467+(0.0120716159479)*(z-1.45)/0.05;
else if(z<=1.55) adjust19=1.01669467062+(0.0178124377525)*(z-1.5)/0.05;
else if(z<=1.6) adjust19=1.03450710837+(0.0166906549404)*(z-1.55)/0.05;
else adjust19=1.05119776331;
end
endfunction
analog function real adjust20;
input z; real z;
begin
if(z<=0.2) adjust20=0.993217389617;
else if(z<=0.25) adjust20=0.993217389617+(-0.00191431847338)*(z-0.2)/0.05;
else if(z<=0.3) adjust20=0.991303071143+(0.00594980808737)*(z-0.25)/0.05;
else if(z<=0.35) adjust20=0.997252879231+(0.0145337812433)*(z-0.3)/0.05;
else if(z<=0.4) adjust20=1.01178666047+(0.0188942697741)*(z-0.35)/0.05;
else if(z<=0.45) adjust20=1.03068093025+(0.0150274875997)*(z-0.4)/0.05;
else if(z<=0.5) adjust20=1.04570841785+(0.00396367442143)*(z-0.45)/0.05;
else if(z<=0.55) adjust20=1.04967209227+(-0.00680731962643)*(z-0.5)/0.05;
else if(z<=0.6) adjust20=1.04286477264+(-0.00830481452761)*(z-0.55)/0.05;
else if(z<=0.65) adjust20=1.03455995811+(0.00163659184066)*(z-0.6)/0.05;
else if(z<=0.7) adjust20=1.03619654996+(0.0141191038491)*(z-0.65)/0.05;
else if(z<=0.75) adjust20=1.0503156538+(0.0122695156814)*(z-0.7)/0.05;
else if(z<=0.8) adjust20=1.06258516949+(-0.0174023414921)*(z-0.75)/0.05;
else if(z<=0.85) adjust20=1.04518282799+(-0.0679312920409)*(z-0.8)/0.05;
else if(z<=0.9) adjust20=0.977251535953+(-0.108963726108)*(z-0.85)/0.05;
else if(z<=0.95) adjust20=0.868287809845+(-0.113292185855)*(z-0.9)/0.05;
else if(z<=1) adjust20=0.75499562399+(-0.05499562399)*(z-0.95)/0.05;
else if(z<=1.05) adjust20=0.7+(0)*(z-1)/0.05;
else if(z<=1.1) adjust20=0.7+(0)*(z-1.05)/0.05;
else if(z<=1.15) adjust20=0.7+(0.0445548718924)*(z-1.1)/0.05;
else if(z<=1.2) adjust20=0.744554871892+(0.100203128612)*(z-1.15)/0.05;
else if(z<=1.25) adjust20=0.844758000504+(0.0964153630929)*(z-1.2)/0.05;
else if(z<=1.3) adjust20=0.941173363597+(0.0663851843538)*(z-1.25)/0.05;
else if(z<=1.35) adjust20=1.00755854795+(0.0305611707672)*(z-1.3)/0.05;
else if(z<=1.4) adjust20=1.03811971872+(0.00821508502458)*(z-1.35)/0.05;
else if(z<=1.45) adjust20=1.04633480374+(0.00331587815787)*(z-1.4)/0.05;
else if(z<=1.5) adjust20=1.0496506819+(0.00758099096448)*(z-1.45)/0.05;
else if(z<=1.55) adjust20=1.05723167287+(0.0107126028241)*(z-1.5)/0.05;
else if(z<=1.6) adjust20=1.06794427569+(0.00725526971612)*(z-1.55)/0.05;
else adjust20=1.07519954541;
end
endfunction
analog function real adjust21;
input z; real z;
begin
if(z<=0.2) adjust21=0.980955085779;
else if(z<=0.25) adjust21=0.980955085779+(0.00178715640683)*(z-0.2)/0.05;
else if(z<=0.3) adjust21=0.982742242185+(0.010499451029)*(z-0.25)/0.05;
else if(z<=0.35) adjust21=0.993241693214+(0.0184446692766)*(z-0.3)/0.05;
else if(z<=0.4) adjust21=1.01168636249+(0.0208296564401)*(z-0.35)/0.05;
else if(z<=0.45) adjust21=1.03251601893+(0.0145475396933)*(z-0.4)/0.05;
else if(z<=0.5) adjust21=1.04706355862+(0.00188724513321)*(z-0.45)/0.05;
else if(z<=0.55) adjust21=1.04895080376+(-0.00908315481132)*(z-0.5)/0.05;
else if(z<=0.6) adjust21=1.03986764895+(-0.0101769296038)*(z-0.55)/0.05;
else if(z<=0.65) adjust21=1.02969071934+(-0.000668617845354)*(z-0.6)/0.05;
else if(z<=0.7) adjust21=1.0290221015+(0.00996581356251)*(z-0.65)/0.05;
else if(z<=0.75) adjust21=1.03898791506+(0.00629015146101)*(z-0.7)/0.05;
else if(z<=0.8) adjust21=1.04527806652+(-0.0218557269358)*(z-0.75)/0.05;
else if(z<=0.85) adjust21=1.02342233958+(-0.0654187703373)*(z-0.8)/0.05;
else if(z<=0.9) adjust21=0.958003569248+(-0.0972050742421)*(z-0.85)/0.05;
else if(z<=0.95) adjust21=0.860798495005+(-0.0957535234869)*(z-0.9)/0.05;
else if(z<=1) adjust21=0.765044971519+(-0.0626079030303)*(z-0.95)/0.05;
else if(z<=1.05) adjust21=0.702437068488+(-0.00243706848818)*(z-1)/0.05;
else if(z<=1.1) adjust21=0.7+(0.0289438888384)*(z-1.05)/0.05;
else if(z<=1.15) adjust21=0.728943888838+(0.0818477927725)*(z-1.1)/0.05;
else if(z<=1.2) adjust21=0.810791681611+(0.101852649644)*(z-1.15)/0.05;
else if(z<=1.25) adjust21=0.912644331255+(0.0916885254319)*(z-1.2)/0.05;
else if(z<=1.3) adjust21=1.00433285669+(0.0594047170046)*(z-1.25)/0.05;
else if(z<=1.35) adjust21=1.06373757369+(0.0255330822686)*(z-1.3)/0.05;
else if(z<=1.4) adjust21=1.08927065596+(0.00577948933054)*(z-1.35)/0.05;
else if(z<=1.45) adjust21=1.09505014529+(0.00109890867655)*(z-1.4)/0.05;
else if(z<=1.5) adjust21=1.09614905397+(0.00287895960624)*(z-1.45)/0.05;
else if(z<=1.55) adjust21=1.09902801357+(0.00244016717003)*(z-1.5)/0.05;
else if(z<=1.6) adjust21=1.10146818074+(-0.00349926647343)*(z-1.55)/0.05;
else adjust21=1.09796891427;
end
endfunction
analog function real adjust22;
input z; real z;
begin
if(z<=0.2) adjust22=0.97105936225;
else if(z<=0.25) adjust22=0.97105936225+(0.00424461765461)*(z-0.2)/0.05;
else if(z<=0.3) adjust22=0.975303979905+(0.0135767534975)*(z-0.25)/0.05;
else if(z<=0.35) adjust22=0.988880733402+(0.0212084147486)*(z-0.3)/0.05;
else if(z<=0.4) adjust22=1.01008914815+(0.0225126398185)*(z-0.35)/0.05;
else if(z<=0.45) adjust22=1.03260178797+(0.0149683311718)*(z-0.4)/0.05;
else if(z<=0.5) adjust22=1.04757011914+(0.00149806304622)*(z-0.45)/0.05;
else if(z<=0.55) adjust22=1.04906818219+(-0.00977311785494)*(z-0.5)/0.05;
else if(z<=0.6) adjust22=1.03929506433+(-0.0113038120449)*(z-0.55)/0.05;
else if(z<=0.65) adjust22=1.02799125229+(-0.00295381868197)*(z-0.6)/0.05;
else if(z<=0.7) adjust22=1.02503743361+(0.00628219235973)*(z-0.65)/0.05;
else if(z<=0.75) adjust22=1.03131962597+(0.00298857066876)*(z-0.7)/0.05;
else if(z<=0.8) adjust22=1.03430819663+(-0.0205079542807)*(z-0.75)/0.05;
else if(z<=0.85) adjust22=1.01380024235+(-0.0554778196479)*(z-0.8)/0.05;
else if(z<=0.9) adjust22=0.958322422705+(-0.0794330591705)*(z-0.85)/0.05;
else if(z<=0.95) adjust22=0.878889363535+(-0.0753377595431)*(z-0.9)/0.05;
else if(z<=1) adjust22=0.803551603992+(-0.0443592987155)*(z-0.95)/0.05;
else if(z<=1.05) adjust22=0.759192305276+(0.00103948154745)*(z-1)/0.05;
else if(z<=1.1) adjust22=0.760231786824+(0.0474043473364)*(z-1.05)/0.05;
else if(z<=1.15) adjust22=0.80763613416+(0.0820674441808)*(z-1.1)/0.05;
else if(z<=1.2) adjust22=0.889703578341+(0.0936086899548)*(z-1.15)/0.05;
else if(z<=1.25) adjust22=0.983312268296+(0.0788238326524)*(z-1.2)/0.05;
else if(z<=1.3) adjust22=1.06213610095+(0.0486962558466)*(z-1.25)/0.05;
else if(z<=1.35) adjust22=1.11083235679+(0.0209899484979)*(z-1.3)/0.05;
else if(z<=1.4) adjust22=1.13182230529+(0.00596400877162)*(z-1.35)/0.05;
else if(z<=1.45) adjust22=1.13778631406+(0.0016716288759)*(z-1.4)/0.05;
else if(z<=1.5) adjust22=1.13945794294+(0.000203474795496)*(z-1.45)/0.05;
else if(z<=1.55) adjust22=1.13966141774+(-0.00453886761147)*(z-1.5)/0.05;
else if(z<=1.6) adjust22=1.13512255012+(-0.0132367817414)*(z-1.55)/0.05;
else adjust22=1.12188576838;
end
endfunction
analog function real adjust23;
input z; real z;
begin
if(z<=0.2) adjust23=0.964367474506;
else if(z<=0.25) adjust23=0.964367474506+(0.0055466251029)*(z-0.2)/0.05;
else if(z<=0.3) adjust23=0.969914099609+(0.0150980104883)*(z-0.25)/0.05;
else if(z<=0.35) adjust23=0.985012110097+(0.0224956795611)*(z-0.3)/0.05;
else if(z<=0.4) adjust23=1.00750778966+(0.0233821174519)*(z-0.35)/0.05;
else if(z<=0.45) adjust23=1.03088990711+(0.0156392232212)*(z-0.4)/0.05;
else if(z<=0.5) adjust23=1.04652913033+(0.00231757502643)*(z-0.45)/0.05;
else if(z<=0.55) adjust23=1.04884670536+(-0.00891436440574)*(z-0.5)/0.05;
else if(z<=0.6) adjust23=1.03993234095+(-0.0112186832108)*(z-0.55)/0.05;
else if(z<=0.65) adjust23=1.02871365774+(-0.00457554446113)*(z-0.6)/0.05;
else if(z<=0.7) adjust23=1.02413811328+(0.00310958400616)*(z-0.65)/0.05;
else if(z<=0.75) adjust23=1.02724769729+(0.000698012231973)*(z-0.7)/0.05;
else if(z<=0.8) adjust23=1.02794570952+(-0.0174577115966)*(z-0.75)/0.05;
else if(z<=0.85) adjust23=1.01048799792+(-0.0437704767852)*(z-0.8)/0.05;
else if(z<=0.9) adjust23=0.966717521137+(-0.0605756466764)*(z-0.85)/0.05;
else if(z<=0.95) adjust23=0.90614187446+(-0.0547415915221)*(z-0.9)/0.05;
else if(z<=1) adjust23=0.851400282938+(-0.0270664107605)*(z-0.95)/0.05;
else if(z<=1.05) adjust23=0.824333872178+(0.0120617873553)*(z-1)/0.05;
else if(z<=1.1) adjust23=0.836395659533+(0.0499952222683)*(z-1.05)/0.05;
else if(z<=1.15) adjust23=0.886390881801+(0.0747828857189)*(z-1.1)/0.05;
else if(z<=1.2) adjust23=0.96117376752+(0.0783520334828)*(z-1.15)/0.05;
else if(z<=1.25) adjust23=1.039525801+(0.0622779827148)*(z-1.2)/0.05;
else if(z<=1.3) adjust23=1.10180378372+(0.0383881193518)*(z-1.25)/0.05;
else if(z<=1.35) adjust23=1.14019190307+(0.0195723284096)*(z-1.3)/0.05;
else if(z<=1.4) adjust23=1.15976423148+(0.0103119582648)*(z-1.35)/0.05;
else if(z<=1.45) adjust23=1.17007618974+(0.00642169840327)*(z-1.4)/0.05;
else if(z<=1.5) adjust23=1.17649788815+(0.00132704238659)*(z-1.45)/0.05;
else if(z<=1.55) adjust23=1.17782493053+(-0.00814319629945)*(z-1.5)/0.05;
else if(z<=1.6) adjust23=1.16968173423+(-0.0200463350594)*(z-1.55)/0.05;
else adjust23=1.14963539917;
end
endfunction
analog function real adjust24;
input z; real z;
begin
if(z<=0.2) adjust24=0.961263527586;
else if(z<=0.25) adjust24=0.961263527586+(0.00595066258864)*(z-0.2)/0.05;
else if(z<=0.3) adjust24=0.967214190175+(0.0152305610185)*(z-0.25)/0.05;
else if(z<=0.35) adjust24=0.982444751194+(0.0222363032254)*(z-0.3)/0.05;
else if(z<=0.4) adjust24=1.00468105442+(0.0230205515777)*(z-0.35)/0.05;
else if(z<=0.45) adjust24=1.027701606+(0.0158219159134)*(z-0.4)/0.05;
else if(z<=0.5) adjust24=1.04352352191+(0.0035221085501)*(z-0.45)/0.05;
else if(z<=0.55) adjust24=1.04704563046+(-0.00705390897205)*(z-0.5)/0.05;
else if(z<=0.6) adjust24=1.03999172149+(-0.00996177080194)*(z-0.55)/0.05;
else if(z<=0.65) adjust24=1.03002995069+(-0.00520876060919)*(z-0.6)/0.05;
else if(z<=0.7) adjust24=1.02482119008+(0.000558571878692)*(z-0.65)/0.05;
else if(z<=0.75) adjust24=1.02537976196+(-0.00156026182405)*(z-0.7)/0.05;
else if(z<=0.8) adjust24=1.02381950013+(-0.015425047251)*(z-0.75)/0.05;
else if(z<=0.85) adjust24=1.00839445288+(-0.0344628272908)*(z-0.8)/0.05;
else if(z<=0.9) adjust24=0.97393162559+(-0.0450630873881)*(z-0.85)/0.05;
else if(z<=0.95) adjust24=0.928868538202+(-0.037611996739)*(z-0.9)/0.05;
else if(z<=1) adjust24=0.891256541463+(-0.0132388996563)*(z-0.95)/0.05;
else if(z<=1.05) adjust24=0.878017641806+(0.0190213407126)*(z-1)/0.05;
else if(z<=1.1) adjust24=0.897038982519+(0.04780178242)*(z-1.05)/0.05;
else if(z<=1.15) adjust24=0.944840764939+(0.0633328249643)*(z-1.1)/0.05;
else if(z<=1.2) adjust24=1.0081735899+(0.0616422778593)*(z-1.15)/0.05;
else if(z<=1.25) adjust24=1.06981586776+(0.0477016907827)*(z-1.2)/0.05;
else if(z<=1.3) adjust24=1.11751755855+(0.032077612315)*(z-1.25)/0.05;
else if(z<=1.35) adjust24=1.14959517086+(0.0224306514007)*(z-1.3)/0.05;
else if(z<=1.4) adjust24=1.17202582226+(0.0185941088811)*(z-1.35)/0.05;
else if(z<=1.45) adjust24=1.19061993114+(0.0150054999692)*(z-1.4)/0.05;
else if(z<=1.5) adjust24=1.20562543111+(0.00648302180161)*(z-1.45)/0.05;
else if(z<=1.55) adjust24=1.21210845291+(-0.00756852833629)*(z-1.5)/0.05;
else if(z<=1.6) adjust24=1.20453992458+(-0.0229806721308)*(z-1.55)/0.05;
else adjust24=1.18155925245;
end
endfunction
analog function real adjust25;
input z; real z;
begin
if(z<=0.2) adjust25=0.961691978472;
else if(z<=0.25) adjust25=0.961691978472+(0.00579972933706)*(z-0.2)/0.05;
else if(z<=0.3) adjust25=0.96749170781+(0.0143338223591)*(z-0.25)/0.05;
else if(z<=0.35) adjust25=0.981825530169+(0.0206494605039)*(z-0.3)/0.05;
else if(z<=0.4) adjust25=1.00247499067+(0.0213300138666)*(z-0.35)/0.05;
else if(z<=0.45) adjust25=1.02380500454+(0.0150052995483)*(z-0.4)/0.05;
else if(z<=0.5) adjust25=1.03881030409+(0.004294435927)*(z-0.45)/0.05;
else if(z<=0.55) adjust25=1.04310474001+(-0.00500140413422)*(z-0.5)/0.05;
else if(z<=0.6) adjust25=1.03810333588+(-0.00800802913632)*(z-0.55)/0.05;
else if(z<=0.65) adjust25=1.03009530674+(-0.00489372238282)*(z-0.6)/0.05;
else if(z<=0.7) adjust25=1.02520158436+(-0.00120151269977)*(z-0.65)/0.05;
else if(z<=0.75) adjust25=1.02400007166+(-0.00386888734422)*(z-0.7)/0.05;
else if(z<=0.8) adjust25=1.02013118432+(-0.0151870445101)*(z-0.75)/0.05;
else if(z<=0.85) adjust25=1.00494413981+(-0.0291781180645)*(z-0.8)/0.05;
else if(z<=0.9) adjust25=0.975766021742+(-0.0351731745634)*(z-0.85)/0.05;
else if(z<=0.95) adjust25=0.940592847179+(-0.0264027099364)*(z-0.9)/0.05;
else if(z<=1) adjust25=0.914190137242+(-0.00472934838682)*(z-0.95)/0.05;
else if(z<=1.05) adjust25=0.909460788856+(0.0216673905467)*(z-1)/0.05;
else if(z<=1.1) adjust25=0.931128179402+(0.0430150207488)*(z-1.05)/0.05;
else if(z<=1.15) adjust25=0.974143200151+(0.0522100234958)*(z-1.1)/0.05;
else if(z<=1.2) adjust25=1.02635322365+(0.0485979052267)*(z-1.15)/0.05;
else if(z<=1.25) adjust25=1.07495112887+(0.0385944771539)*(z-1.2)/0.05;
else if(z<=1.3) adjust25=1.11354560603+(0.0305786211478)*(z-1.25)/0.05;
else if(z<=1.35) adjust25=1.14412422718+(0.0281790546008)*(z-1.3)/0.05;
else if(z<=1.4) adjust25=1.17230328178+(0.0283718925233)*(z-1.35)/0.05;
else if(z<=1.45) adjust25=1.2006751743+(0.0250017951903)*(z-1.4)/0.05;
else if(z<=1.5) adjust25=1.22567696949+(0.0139527603845)*(z-1.45)/0.05;
else if(z<=1.55) adjust25=1.23962972987+(-0.0036454502581)*(z-1.5)/0.05;
else if(z<=1.6) adjust25=1.23598427962+(-0.022189885063)*(z-1.55)/0.05;
else adjust25=1.21379439455;
end
endfunction
analog function real adjust26;
input z; real z;
begin
if(z<=0.2) adjust26=0.96520482655;
else if(z<=0.25) adjust26=0.96520482655+(0.00543225313029)*(z-0.2)/0.05;
else if(z<=0.3) adjust26=0.97063707968+(0.0128556385005)*(z-0.25)/0.05;
else if(z<=0.35) adjust26=0.98349271818+(0.0181720344864)*(z-0.3)/0.05;
else if(z<=0.4) adjust26=1.00166475267+(0.0185591859324)*(z-0.35)/0.05;
else if(z<=0.45) adjust26=1.0202239386+(0.0130821409288)*(z-0.4)/0.05;
else if(z<=0.5) adjust26=1.03330607953+(0.00413164226765)*(z-0.45)/0.05;
else if(z<=0.55) adjust26=1.0374377218+(-0.00349187896989)*(z-0.5)/0.05;
else if(z<=0.6) adjust26=1.03394584283+(-0.00602626342143)*(z-0.55)/0.05;
else if(z<=0.65) adjust26=1.0279195794+(-0.00396575163506)*(z-0.6)/0.05;
else if(z<=0.7) adjust26=1.02395382777+(-0.00205393822164)*(z-0.65)/0.05;
else if(z<=0.75) adjust26=1.02189988955+(-0.00568713203047)*(z-0.7)/0.05;
else if(z<=0.8) adjust26=1.01621275752+(-0.0158968408733)*(z-0.75)/0.05;
else if(z<=0.85) adjust26=1.00031591664+(-0.0269818613227)*(z-0.8)/0.05;
else if(z<=0.9) adjust26=0.973334055321+(-0.0301880558226)*(z-0.85)/0.05;
else if(z<=0.95) adjust26=0.943145999499+(-0.0207063520958)*(z-0.9)/0.05;
else if(z<=1) adjust26=0.922439647403+(-0.00101092613618)*(z-0.95)/0.05;
else if(z<=1.05) adjust26=0.921428721267+(0.021377752354)*(z-1)/0.05;
else if(z<=1.1) adjust26=0.942806473621+(0.0381642522902)*(z-1.05)/0.05;
else if(z<=1.15) adjust26=0.980970725911+(0.0443363081397)*(z-1.1)/0.05;
else if(z<=1.2) adjust26=1.02530703405+(0.0410475899815)*(z-1.15)/0.05;
else if(z<=1.25) adjust26=1.06635462403+(0.0347299206994)*(z-1.2)/0.05;
else if(z<=1.3) adjust26=1.10108454473+(0.0318051728482)*(z-1.25)/0.05;
else if(z<=1.35) adjust26=1.13288971758+(0.0336082458358)*(z-1.3)/0.05;
else if(z<=1.4) adjust26=1.16649796342+(0.0359536225779)*(z-1.35)/0.05;
else if(z<=1.45) adjust26=1.20245158599+(0.0327717453654)*(z-1.4)/0.05;
else if(z<=1.5) adjust26=1.23522333136+(0.020666046489)*(z-1.45)/0.05;
else if(z<=1.55) adjust26=1.25588937785+(0.0014972555994)*(z-1.5)/0.05;
else if(z<=1.6) adjust26=1.25738663345+(-0.0187536901937)*(z-1.55)/0.05;
else adjust26=1.23863294325;
end
endfunction
analog function real adjust27;
input z; real z;
begin
if(z<=0.2) adjust27=0.971023010973;
else if(z<=0.25) adjust27=0.971023010973+(0.00509878046145)*(z-0.2)/0.05;
else if(z<=0.3) adjust27=0.976121791435+(0.0112101128175)*(z-0.25)/0.05;
else if(z<=0.35) adjust27=0.987331904252+(0.0153161094435)*(z-0.3)/0.05;
else if(z<=0.4) adjust27=1.0026480137+(0.015187648999)*(z-0.35)/0.05;
else if(z<=0.45) adjust27=1.01783566269+(0.0103304913655)*(z-0.4)/0.05;
else if(z<=0.5) adjust27=1.02816615406+(0.00297944452132)*(z-0.45)/0.05;
else if(z<=0.55) adjust27=1.03114559858+(-0.00291321263679)*(z-0.5)/0.05;
else if(z<=0.6) adjust27=1.02823238594+(-0.00457533348533)*(z-0.55)/0.05;
else if(z<=0.65) adjust27=1.02365705246+(-0.0028785173865)*(z-0.6)/0.05;
else if(z<=0.7) adjust27=1.02077853507+(-0.00204215369033)*(z-0.65)/0.05;
else if(z<=0.75) adjust27=1.01873638138+(-0.00637554856989)*(z-0.7)/0.05;
else if(z<=0.8) adjust27=1.01236083281+(-0.0160622793826)*(z-0.75)/0.05;
else if(z<=0.85) adjust27=0.99629855343+(-0.0256079226221)*(z-0.8)/0.05;
else if(z<=0.9) adjust27=0.970690630808+(-0.0274605425725)*(z-0.85)/0.05;
else if(z<=0.95) adjust27=0.943230088236+(-0.017942872817)*(z-0.9)/0.05;
else if(z<=1) adjust27=0.925287215419+(0.000248786959584)*(z-0.95)/0.05;
else if(z<=1.05) adjust27=0.925536002378+(0.0202166574889)*(z-1)/0.05;
else if(z<=1.1) adjust27=0.945752659867+(0.034757817499)*(z-1.05)/0.05;
else if(z<=1.15) adjust27=0.980510477366+(0.0400115833063)*(z-1.1)/0.05;
else if(z<=1.2) adjust27=1.02052206067+(0.0376393653891)*(z-1.15)/0.05;
else if(z<=1.25) adjust27=1.05816142606+(0.0334298211243)*(z-1.2)/0.05;
else if(z<=1.3) adjust27=1.09159124719+(0.032529715968)*(z-1.25)/0.05;
else if(z<=1.35) adjust27=1.12412096315+(0.0354497173384)*(z-1.3)/0.05;
else if(z<=1.4) adjust27=1.15957068049+(0.0381103514738)*(z-1.35)/0.05;
else if(z<=1.45) adjust27=1.19768103197+(0.0351182736029)*(z-1.4)/0.05;
else if(z<=1.5) adjust27=1.23279930557+(0.0236267968531)*(z-1.45)/0.05;
else if(z<=1.55) adjust27=1.25642610242+(0.00540058021341)*(z-1.5)/0.05;
else if(z<=1.6) adjust27=1.26182668264+(-0.0142572715258)*(z-1.55)/0.05;
else adjust27=1.24756941111;
end
endfunction
analog function real adjust28;
input z; real z;
begin
if(z<=0.2) adjust28=0.978132085868;
else if(z<=0.25) adjust28=0.978132085868+(0.00490934121937)*(z-0.2)/0.05;
else if(z<=0.3) adjust28=0.983041427088+(0.00967879389723)*(z-0.25)/0.05;
else if(z<=0.35) adjust28=0.992720220985+(0.0125206917042)*(z-0.3)/0.05;
else if(z<=0.4) adjust28=1.00524091269+(0.0117449713645)*(z-0.35)/0.05;
else if(z<=0.45) adjust28=1.01698588405+(0.00725021391069)*(z-0.4)/0.05;
else if(z<=0.5) adjust28=1.02423609796+(0.00116357309913)*(z-0.45)/0.05;
else if(z<=0.55) adjust28=1.02539967106+(-0.00322136869827)*(z-0.5)/0.05;
else if(z<=0.6) adjust28=1.02217830237+(-0.00389306327202)*(z-0.55)/0.05;
else if(z<=0.65) adjust28=1.01828523909+(-0.00200460791018)*(z-0.6)/0.05;
else if(z<=0.7) adjust28=1.01628063118+(-0.0013914123738)*(z-0.65)/0.05;
else if(z<=0.75) adjust28=1.01488921881+(-0.00565033273568)*(z-0.7)/0.05;
else if(z<=0.8) adjust28=1.00923888607+(-0.0145660655544)*(z-0.75)/0.05;
else if(z<=0.85) adjust28=0.994672820519+(-0.023018003692)*(z-0.8)/0.05;
else if(z<=0.9) adjust28=0.971654816827+(-0.0243165143508)*(z-0.85)/0.05;
else if(z<=0.95) adjust28=0.947338302476+(-0.0153300691392)*(z-0.9)/0.05;
else if(z<=1) adjust28=0.932008233337+(0.00141722072446)*(z-0.95)/0.05;
else if(z<=1.05) adjust28=0.933425454062+(0.0196756982179)*(z-1)/0.05;
else if(z<=1.1) adjust28=0.95310115228+(0.032969813143)*(z-1.05)/0.05;
else if(z<=1.15) adjust28=0.986070965422+(0.0378650889836)*(z-1.1)/0.05;
else if(z<=1.2) adjust28=1.02393605441+(0.0357940095278)*(z-1.15)/0.05;
else if(z<=1.25) adjust28=1.05973006393+(0.0317534773369)*(z-1.2)/0.05;
else if(z<=1.3) adjust28=1.09148354127+(0.0302384979572)*(z-1.25)/0.05;
else if(z<=1.35) adjust28=1.12172203923+(0.0318904745629)*(z-1.3)/0.05;
else if(z<=1.4) adjust28=1.15361251379+(0.0335251676437)*(z-1.35)/0.05;
else if(z<=1.45) adjust28=1.18713768143+(0.0308271798833)*(z-1.4)/0.05;
else if(z<=1.5) adjust28=1.21796486132+(0.0214277765021)*(z-1.45)/0.05;
else if(z<=1.55) adjust28=1.23939263782+(0.00646948161767)*(z-1.5)/0.05;
else if(z<=1.6) adjust28=1.24586211944+(-0.0101657766355)*(z-1.55)/0.05;
else adjust28=1.2356963428;
end
endfunction
analog begin
@(initial_step) begin vinit=V(vin); gateinit=1.8-V(clock); end
if(V(vin)<=0.2) correction=adjust0(V(vhold));
else if(V(vin)<=0.25) correction=adjust0(V(vhold))+(adjust1(V(vhold))-adjust0(V(vhold)))*(V(vin)-0.2)/0.05;
else if(V(vin)<=0.3) correction=adjust1(V(vhold))+(adjust2(V(vhold))-adjust1(V(vhold)))*(V(vin)-0.25)/0.05;
else if(V(vin)<=0.35) correction=adjust2(V(vhold))+(adjust3(V(vhold))-adjust2(V(vhold)))*(V(vin)-0.3)/0.05;
else if(V(vin)<=0.4) correction=adjust3(V(vhold))+(adjust4(V(vhold))-adjust3(V(vhold)))*(V(vin)-0.35)/0.05;
else if(V(vin)<=0.45) correction=adjust4(V(vhold))+(adjust5(V(vhold))-adjust4(V(vhold)))*(V(vin)-0.4)/0.05;
else if(V(vin)<=0.5) correction=adjust5(V(vhold))+(adjust6(V(vhold))-adjust5(V(vhold)))*(V(vin)-0.45)/0.05;
else if(V(vin)<=0.55) correction=adjust6(V(vhold))+(adjust7(V(vhold))-adjust6(V(vhold)))*(V(vin)-0.5)/0.05;
else if(V(vin)<=0.6) correction=adjust7(V(vhold))+(adjust8(V(vhold))-adjust7(V(vhold)))*(V(vin)-0.55)/0.05;
else if(V(vin)<=0.65) correction=adjust8(V(vhold))+(adjust9(V(vhold))-adjust8(V(vhold)))*(V(vin)-0.6)/0.05;
else if(V(vin)<=0.7) correction=adjust9(V(vhold))+(adjust10(V(vhold))-adjust9(V(vhold)))*(V(vin)-0.65)/0.05;
else if(V(vin)<=0.75) correction=adjust10(V(vhold))+(adjust11(V(vhold))-adjust10(V(vhold)))*(V(vin)-0.7)/0.05;
else if(V(vin)<=0.8) correction=adjust11(V(vhold))+(adjust12(V(vhold))-adjust11(V(vhold)))*(V(vin)-0.75)/0.05;
else if(V(vin)<=0.85) correction=adjust12(V(vhold))+(adjust13(V(vhold))-adjust12(V(vhold)))*(V(vin)-0.8)/0.05;
else if(V(vin)<=0.9) correction=adjust13(V(vhold))+(adjust14(V(vhold))-adjust13(V(vhold)))*(V(vin)-0.85)/0.05;
else if(V(vin)<=0.95) correction=adjust14(V(vhold))+(adjust15(V(vhold))-adjust14(V(vhold)))*(V(vin)-0.9)/0.05;
else if(V(vin)<=1) correction=adjust15(V(vhold))+(adjust16(V(vhold))-adjust15(V(vhold)))*(V(vin)-0.95)/0.05;
else if(V(vin)<=1.05) correction=adjust16(V(vhold))+(adjust17(V(vhold))-adjust16(V(vhold)))*(V(vin)-1)/0.05;
else if(V(vin)<=1.1) correction=adjust17(V(vhold))+(adjust18(V(vhold))-adjust17(V(vhold)))*(V(vin)-1.05)/0.05;
else if(V(vin)<=1.15) correction=adjust18(V(vhold))+(adjust19(V(vhold))-adjust18(V(vhold)))*(V(vin)-1.1)/0.05;
else if(V(vin)<=1.2) correction=adjust19(V(vhold))+(adjust20(V(vhold))-adjust19(V(vhold)))*(V(vin)-1.15)/0.05;
else if(V(vin)<=1.25) correction=adjust20(V(vhold))+(adjust21(V(vhold))-adjust20(V(vhold)))*(V(vin)-1.2)/0.05;
else if(V(vin)<=1.3) correction=adjust21(V(vhold))+(adjust22(V(vhold))-adjust21(V(vhold)))*(V(vin)-1.25)/0.05;
else if(V(vin)<=1.35) correction=adjust22(V(vhold))+(adjust23(V(vhold))-adjust22(V(vhold)))*(V(vin)-1.3)/0.05;
else if(V(vin)<=1.4) correction=adjust23(V(vhold))+(adjust24(V(vhold))-adjust23(V(vhold)))*(V(vin)-1.35)/0.05;
else if(V(vin)<=1.45) correction=adjust24(V(vhold))+(adjust25(V(vhold))-adjust24(V(vhold)))*(V(vin)-1.4)/0.05;
else if(V(vin)<=1.5) correction=adjust25(V(vhold))+(adjust26(V(vhold))-adjust25(V(vhold)))*(V(vin)-1.45)/0.05;
else if(V(vin)<=1.55) correction=adjust26(V(vhold))+(adjust27(V(vhold))-adjust26(V(vhold)))*(V(vin)-1.5)/0.05;
else if(V(vin)<=1.6) correction=adjust27(V(vhold))+(adjust28(V(vhold))-adjust27(V(vhold)))*(V(vin)-1.55)/0.05;
else correction=adjust28(V(vhold));
target=1.8-V(clock);
tau=(target>V(invstate)) ? 0.09e-9 : 0.08e-9;
rate=correction*(channel_n(V(vin),V(vhold),V(invstate))+channel_p(V(vin),V(vhold),V(clock)));
V(invstate) <+ idt((target-V(invstate))/tau,gateinit);
V(vhold) <+ idt((V(clock)<0.9 ? 0.4e9 : 0.0)*(V(vin)-V(vhold)),vinit);
$bound_step(5p);
end
endmodule
