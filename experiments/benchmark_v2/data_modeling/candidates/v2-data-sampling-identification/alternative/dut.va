`include "constants.vams"
`include "disciplines.vams"
module sampling_model(vin, clock, vhold);
input vin, clock; output vhold;
electrical vin, clock, vhold, state;
real vinit, rate, gate;
analog function real rate0;
input z; real z;
begin
if(z<=0.2) rate0=2.81095991862;
else if(z<=0.3) rate0=2.81095991862+(-0.248714437408)*(z-0.2)/0.1;
else if(z<=0.4) rate0=2.56224548121+(-0.271394671388)*(z-0.3)/0.1;
else if(z<=0.5) rate0=2.29085080982+(-0.251830927841)*(z-0.4)/0.1;
else if(z<=0.6) rate0=2.03901988198+(-0.25413543733)*(z-0.5)/0.1;
else if(z<=0.7) rate0=1.78488444465+(-0.247244369914)*(z-0.6)/0.1;
else if(z<=0.8) rate0=1.53764007473+(-0.206167874469)*(z-0.7)/0.1;
else if(z<=0.9) rate0=1.33147220027+(-0.163515831629)*(z-0.8)/0.1;
else if(z<=1) rate0=1.16795636864+(-0.126548551162)*(z-0.9)/0.1;
else if(z<=1.1) rate0=1.04140781747+(-0.0956944687514)*(z-1)/0.1;
else if(z<=1.2) rate0=0.945713348723+(-0.0672177699863)*(z-1.1)/0.1;
else if(z<=1.3) rate0=0.878495578737+(-0.040551545144)*(z-1.2)/0.1;
else if(z<=1.4) rate0=0.837944033593+(0)*(z-1.3)/0.1;
else if(z<=1.5) rate0=0.837944033593+(0)*(z-1.4)/0.1;
else if(z<=1.6) rate0=0.837944033593+(0)*(z-1.5)/0.1;
else rate0=0.837944033593;
end
endfunction
analog function real rate1;
input z; real z;
begin
if(z<=0.2) rate1=2.56512955264;
else if(z<=0.3) rate1=2.56512955264+(-0.043797562897)*(z-0.2)/0.1;
else if(z<=0.4) rate1=2.52133198974+(-0.276894312884)*(z-0.3)/0.1;
else if(z<=0.5) rate1=2.24443767686+(-0.261343830817)*(z-0.4)/0.1;
else if(z<=0.6) rate1=1.98309384604+(-0.243704285333)*(z-0.5)/0.1;
else if(z<=0.7) rate1=1.73938956071+(-0.244514830319)*(z-0.6)/0.1;
else if(z<=0.8) rate1=1.49487473039+(-0.222326164449)*(z-0.7)/0.1;
else if(z<=0.9) rate1=1.27254856594+(-0.176490581175)*(z-0.8)/0.1;
else if(z<=1) rate1=1.09605798477+(-0.134283573354)*(z-0.9)/0.1;
else if(z<=1.1) rate1=0.961774411411+(-0.0975098044314)*(z-1)/0.1;
else if(z<=1.2) rate1=0.86426460698+(-0.0655348572344)*(z-1.1)/0.1;
else if(z<=1.3) rate1=0.798729749746+(-0.044050594555)*(z-1.2)/0.1;
else if(z<=1.4) rate1=0.754679155191+(-0.0103195447465)*(z-1.3)/0.1;
else if(z<=1.5) rate1=0.744359610444+(0)*(z-1.4)/0.1;
else if(z<=1.6) rate1=0.744359610444+(0)*(z-1.5)/0.1;
else rate1=0.744359610444;
end
endfunction
analog function real rate2;
input z; real z;
begin
if(z<=0.2) rate2=1.999210635;
else if(z<=0.3) rate2=1.999210635+(0)*(z-0.2)/0.1;
else if(z<=0.4) rate2=1.999210635+(-0.0509759459336)*(z-0.3)/0.1;
else if(z<=0.5) rate2=1.94823468906+(-0.142574938894)*(z-0.4)/0.1;
else if(z<=0.6) rate2=1.80565975017+(-0.253386351962)*(z-0.5)/0.1;
else if(z<=0.7) rate2=1.55227339821+(-0.23350522888)*(z-0.6)/0.1;
else if(z<=0.8) rate2=1.31876816933+(-0.219266492588)*(z-0.7)/0.1;
else if(z<=0.9) rate2=1.09950167674+(-0.197005959747)*(z-0.8)/0.1;
else if(z<=1) rate2=0.902495716991+(-0.146985759904)*(z-0.9)/0.1;
else if(z<=1.1) rate2=0.755509957087+(-0.0980266768479)*(z-1)/0.1;
else if(z<=1.2) rate2=0.657483280239+(-0.0573495060548)*(z-1.1)/0.1;
else if(z<=1.3) rate2=0.600133774184+(-0.0299864486302)*(z-1.2)/0.1;
else if(z<=1.4) rate2=0.570147325554+(-0.0150312746255)*(z-1.3)/0.1;
else if(z<=1.5) rate2=0.555116050928+(-0.00200193738125)*(z-1.4)/0.1;
else if(z<=1.6) rate2=0.553114113547+(0)*(z-1.5)/0.1;
else rate2=0.553114113547;
end
endfunction
analog function real rate3;
input z; real z;
begin
if(z<=0.2) rate3=1.74186949585;
else if(z<=0.3) rate3=1.74186949585+(0)*(z-0.2)/0.1;
else if(z<=0.4) rate3=1.74186949585+(-0.0243831344311)*(z-0.3)/0.1;
else if(z<=0.5) rate3=1.71748636142+(-0.131205171361)*(z-0.4)/0.1;
else if(z<=0.6) rate3=1.58628119005+(-0.170738884434)*(z-0.5)/0.1;
else if(z<=0.7) rate3=1.41554230562+(-0.23629159214)*(z-0.6)/0.1;
else if(z<=0.8) rate3=1.17925071348+(-0.214245726897)*(z-0.7)/0.1;
else if(z<=0.9) rate3=0.965004986583+(-0.194606738507)*(z-0.8)/0.1;
else if(z<=1) rate3=0.770398248077+(-0.149458145583)*(z-0.9)/0.1;
else if(z<=1.1) rate3=0.620940102493+(-0.0931915137482)*(z-1)/0.1;
else if(z<=1.2) rate3=0.527748588745+(-0.0480255176747)*(z-1.1)/0.1;
else if(z<=1.3) rate3=0.47972307107+(-0.0192741431178)*(z-1.2)/0.1;
else if(z<=1.4) rate3=0.460448927953+(-0.0027760137169)*(z-1.3)/0.1;
else if(z<=1.5) rate3=0.457672914236+(0.000212265933322)*(z-1.4)/0.1;
else if(z<=1.6) rate3=0.457885180169+(0)*(z-1.5)/0.1;
else rate3=0.457885180169;
end
endfunction
analog function real rate4;
input z; real z;
begin
if(z<=0.2) rate4=1.05623957094;
else if(z<=0.3) rate4=1.05623957094+(0)*(z-0.2)/0.1;
else if(z<=0.4) rate4=1.05623957094+(0)*(z-0.3)/0.1;
else if(z<=0.5) rate4=1.05623957094+(-0.102325409515)*(z-0.4)/0.1;
else if(z<=0.6) rate4=0.953914161427+(-0.146813110889)*(z-0.5)/0.1;
else if(z<=0.7) rate4=0.807101050538+(-0.180337154849)*(z-0.6)/0.1;
else if(z<=0.8) rate4=0.626763895689+(-0.208421724324)*(z-0.7)/0.1;
else if(z<=0.9) rate4=0.418342171365+(-0.150215424217)*(z-0.8)/0.1;
else if(z<=1) rate4=0.268126747148+(-0.0592683978013)*(z-0.9)/0.1;
else if(z<=1.1) rate4=0.208858349347+(-0.0592683978013)*(z-1)/0.1;
else if(z<=1.2) rate4=0.149589951545+(-0.0270676388016)*(z-1.1)/0.1;
else if(z<=1.3) rate4=0.122522312744+(0.0389824155476)*(z-1.2)/0.1;
else if(z<=1.4) rate4=0.161504728291+(0.0434318433355)*(z-1.3)/0.1;
else if(z<=1.5) rate4=0.204936571627+(0.0440530120215)*(z-1.4)/0.1;
else if(z<=1.6) rate4=0.248989583648+(0.00737707641569)*(z-1.5)/0.1;
else rate4=0.256366660064;
end
endfunction
analog function real rate5;
input z; real z;
begin
if(z<=0.2) rate5=0.794428934686;
else if(z<=0.3) rate5=0.794428934686+(0)*(z-0.2)/0.1;
else if(z<=0.4) rate5=0.794428934686+(0)*(z-0.3)/0.1;
else if(z<=0.5) rate5=0.794428934686+(-0.0960002398157)*(z-0.4)/0.1;
else if(z<=0.6) rate5=0.698428694871+(-0.141578206505)*(z-0.5)/0.1;
else if(z<=0.7) rate5=0.556850488366+(-0.160938830512)*(z-0.6)/0.1;
else if(z<=0.8) rate5=0.395911657854+(-0.167845823628)*(z-0.7)/0.1;
else if(z<=0.9) rate5=0.228065834226+(-0.127732621134)*(z-0.8)/0.1;
else if(z<=1) rate5=0.100333213092+(0.00978770198001)*(z-0.9)/0.1;
else if(z<=1.1) rate5=0.110120915072+(0.0206490192795)*(z-1)/0.1;
else if(z<=1.2) rate5=0.130769934351+(0.0206490192795)*(z-1.1)/0.1;
else if(z<=1.3) rate5=0.151418953631+(0.0414723975024)*(z-1.2)/0.1;
else if(z<=1.4) rate5=0.192891351133+(0.0522170247988)*(z-1.3)/0.1;
else if(z<=1.5) rate5=0.245108375932+(0.0493508828111)*(z-1.4)/0.1;
else if(z<=1.6) rate5=0.294459258743+(0.0133455470958)*(z-1.5)/0.1;
else rate5=0.307804805839;
end
endfunction
analog function real rate6;
input z; real z;
begin
if(z<=0.2) rate6=0.719910789413;
else if(z<=0.3) rate6=0.719910789413+(0)*(z-0.2)/0.1;
else if(z<=0.4) rate6=0.719910789413+(0)*(z-0.3)/0.1;
else if(z<=0.5) rate6=0.719910789413+(-0.0814507719312)*(z-0.4)/0.1;
else if(z<=0.6) rate6=0.638460017482+(-0.131299019152)*(z-0.5)/0.1;
else if(z<=0.7) rate6=0.50716099833+(-0.144098661882)*(z-0.6)/0.1;
else if(z<=0.8) rate6=0.363062336448+(-0.14208193065)*(z-0.7)/0.1;
else if(z<=0.9) rate6=0.220980405798+(-0.0971696932472)*(z-0.8)/0.1;
else if(z<=1) rate6=0.123810712551+(-0.0014423280945)*(z-0.9)/0.1;
else if(z<=1.1) rate6=0.122368384456+(0.0351700785277)*(z-1)/0.1;
else if(z<=1.2) rate6=0.157538462984+(0.0351700785277)*(z-1.1)/0.1;
else if(z<=1.3) rate6=0.192708541511+(0.0390864654652)*(z-1.2)/0.1;
else if(z<=1.4) rate6=0.231795006977+(0.0533746278597)*(z-1.3)/0.1;
else if(z<=1.5) rate6=0.285169634836+(0.0497364973923)*(z-1.4)/0.1;
else if(z<=1.6) rate6=0.334906132229+(0.016887144765)*(z-1.5)/0.1;
else rate6=0.351793276994;
end
endfunction
analog function real rate7;
input z; real z;
begin
if(z<=0.2) rate7=0.635736660967;
else if(z<=0.3) rate7=0.635736660967+(0)*(z-0.2)/0.1;
else if(z<=0.4) rate7=0.635736660967+(0)*(z-0.3)/0.1;
else if(z<=0.5) rate7=0.635736660967+(-0.0417627151564)*(z-0.4)/0.1;
else if(z<=0.6) rate7=0.593973945811+(-0.108387088745)*(z-0.5)/0.1;
else if(z<=0.7) rate7=0.485586857065+(-0.113715665067)*(z-0.6)/0.1;
else if(z<=0.8) rate7=0.371871191998+(-0.103613206564)*(z-0.7)/0.1;
else if(z<=0.9) rate7=0.268257985434+(-0.0608597087273)*(z-0.8)/0.1;
else if(z<=1) rate7=0.207398276707+(0.00368687947133)*(z-0.9)/0.1;
else if(z<=1.1) rate7=0.211085156178+(0.0342442700754)*(z-1)/0.1;
else if(z<=1.2) rate7=0.245329426253+(0.0404245379497)*(z-1.1)/0.1;
else if(z<=1.3) rate7=0.285753964203+(0.0424254635904)*(z-1.2)/0.1;
else if(z<=1.4) rate7=0.328179427794+(0.0424254635904)*(z-1.3)/0.1;
else if(z<=1.5) rate7=0.370604891384+(0.0486197692231)*(z-1.4)/0.1;
else if(z<=1.6) rate7=0.419224660607+(0.0285654218953)*(z-1.5)/0.1;
else rate7=0.447790082502;
end
endfunction
analog function real rate8;
input z; real z;
begin
if(z<=0.2) rate8=0.613211164049;
else if(z<=0.3) rate8=0.613211164049+(0)*(z-0.2)/0.1;
else if(z<=0.4) rate8=0.613211164049+(0)*(z-0.3)/0.1;
else if(z<=0.5) rate8=0.613211164049+(-0.0206643664377)*(z-0.4)/0.1;
else if(z<=0.6) rate8=0.592546797611+(-0.0979269289298)*(z-0.5)/0.1;
else if(z<=0.7) rate8=0.494619868682+(-0.101693141488)*(z-0.6)/0.1;
else if(z<=0.8) rate8=0.392926727193+(-0.0902730490125)*(z-0.7)/0.1;
else if(z<=0.9) rate8=0.302653678181+(-0.0503899012203)*(z-0.8)/0.1;
else if(z<=1) rate8=0.25226377696+(0.00751984976745)*(z-0.9)/0.1;
else if(z<=1.1) rate8=0.259783626728+(0.0350390957975)*(z-1)/0.1;
else if(z<=1.2) rate8=0.294822722525+(0.0403396276789)*(z-1.1)/0.1;
else if(z<=1.3) rate8=0.335162350204+(0.041476403537)*(z-1.2)/0.1;
else if(z<=1.4) rate8=0.376638753741+(0.0431430958843)*(z-1.3)/0.1;
else if(z<=1.5) rate8=0.419781849626+(0.0434245884308)*(z-1.4)/0.1;
else if(z<=1.6) rate8=0.463206438056+(0.0359684940808)*(z-1.5)/0.1;
else rate8=0.499174932137;
end
endfunction
analog function real rate9;
input z; real z;
begin
if(z<=0.2) rate9=0.598891173952;
else if(z<=0.3) rate9=0.598891173952+(0)*(z-0.2)/0.1;
else if(z<=0.4) rate9=0.598891173952+(0)*(z-0.3)/0.1;
else if(z<=0.5) rate9=0.598891173952+(-0.000149358954367)*(z-0.4)/0.1;
else if(z<=0.6) rate9=0.598741814998+(-0.0883143773375)*(z-0.5)/0.1;
else if(z<=0.7) rate9=0.51042743766+(-0.0914804119833)*(z-0.6)/0.1;
else if(z<=0.8) rate9=0.418947025677+(-0.0796981687258)*(z-0.7)/0.1;
else if(z<=0.9) rate9=0.339248856951+(-0.0427962022411)*(z-0.8)/0.1;
else if(z<=1) rate9=0.29645265471+(0.00979704346702)*(z-0.9)/0.1;
else if(z<=1.1) rate9=0.306249698177+(0.0351975467312)*(z-1)/0.1;
else if(z<=1.2) rate9=0.341447244908+(0.0403593987772)*(z-1.1)/0.1;
else if(z<=1.3) rate9=0.381806643685+(0.0414526648632)*(z-1.2)/0.1;
else if(z<=1.4) rate9=0.423259308548+(0.0421682171274)*(z-1.3)/0.1;
else if(z<=1.5) rate9=0.465427525676+(0.0282462314181)*(z-1.4)/0.1;
else if(z<=1.6) rate9=0.493673757094+(0)*(z-1.5)/0.1;
else rate9=0.493673757094;
end
endfunction
analog begin
@(initial_step) vinit=V(vin);
if(V(vin)<=0.2) rate=rate0(V(state));
else if(V(vin)<=0.3) rate=rate0(V(state))+(rate1(V(state))-rate0(V(state)))*(V(vin)-0.2)/0.1;
else if(V(vin)<=0.5) rate=rate1(V(state))+(rate2(V(state))-rate1(V(state)))*(V(vin)-0.3)/0.2;
else if(V(vin)<=0.6) rate=rate2(V(state))+(rate3(V(state))-rate2(V(state)))*(V(vin)-0.5)/0.1;
else if(V(vin)<=0.9) rate=rate3(V(state))+(rate4(V(state))-rate3(V(state)))*(V(vin)-0.6)/0.3;
else if(V(vin)<=1.1) rate=rate4(V(state))+(rate5(V(state))-rate4(V(state)))*(V(vin)-0.9)/0.2;
else if(V(vin)<=1.2) rate=rate5(V(state))+(rate6(V(state))-rate5(V(state)))*(V(vin)-1.1)/0.1;
else if(V(vin)<=1.4) rate=rate6(V(state))+(rate7(V(state))-rate6(V(state)))*(V(vin)-1.2)/0.2;
else if(V(vin)<=1.5) rate=rate7(V(state))+(rate8(V(state))-rate7(V(state)))*(V(vin)-1.4)/0.1;
else if(V(vin)<=1.6) rate=rate8(V(state))+(rate9(V(state))-rate8(V(state)))*(V(vin)-1.5)/0.1;
else rate=rate9(V(state));
gate=transition(V(clock)<0.9 ? 1.0 : 0.0,65p,35p,35p);
I(state) <+ 1e-12*ddt(V(state));
I(state) <+ gate*(V(state)-V(vin))*rate*1e-3;
V(vhold) <+ V(state);
$bound_step(10p);
end
endmodule
