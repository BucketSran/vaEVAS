`include "constants.vams"
`include "disciplines.vams"
module sampling_model(vin, clock, vhold);
input vin, clock; output vhold;
electrical vin, clock, vhold;
real vinit, rate, gate;
analog function real rate0;
input z; real z;
begin
if(z<=0.2) rate0=2.81095991862;
else if(z<=0.25) rate0=2.81095991862+(-0.10137073639)*(z-0.2)/0.05;
else if(z<=0.3) rate0=2.70958918222+(-0.147343701018)*(z-0.25)/0.05;
else if(z<=0.35) rate0=2.56224548121+(-0.139151814907)*(z-0.3)/0.05;
else if(z<=0.4) rate0=2.4230936663+(-0.132242856481)*(z-0.35)/0.05;
else if(z<=0.45) rate0=2.29085080982+(-0.12709039351)*(z-0.4)/0.05;
else if(z<=0.5) rate0=2.16376041631+(-0.124740534331)*(z-0.45)/0.05;
else if(z<=0.55) rate0=2.03901988198+(-0.125756551214)*(z-0.5)/0.05;
else if(z<=0.6) rate0=1.91326333077+(-0.128378886116)*(z-0.55)/0.05;
else if(z<=0.65) rate0=1.78488444465+(-0.127056038423)*(z-0.6)/0.05;
else if(z<=0.7) rate0=1.65782840623+(-0.120188331491)*(z-0.65)/0.05;
else if(z<=0.75) rate0=1.53764007473+(-0.108628177839)*(z-0.7)/0.05;
else if(z<=0.8) rate0=1.4290118969+(-0.0975396966307)*(z-0.75)/0.05;
else if(z<=0.85) rate0=1.33147220027+(-0.086908619626)*(z-0.8)/0.05;
else if(z<=0.9) rate0=1.24456358064+(-0.0766072120027)*(z-0.85)/0.05;
else if(z<=0.95) rate0=1.16795636864+(-0.0672390727082)*(z-0.9)/0.05;
else if(z<=1) rate0=1.10071729593+(-0.0593094784537)*(z-0.95)/0.05;
else if(z<=1.05) rate0=1.04140781747+(-0.0516151788294)*(z-1)/0.05;
else if(z<=1.1) rate0=0.989792638645+(-0.044079289922)*(z-1.05)/0.05;
else if(z<=1.15) rate0=0.945713348723+(-0.0367321252178)*(z-1.1)/0.05;
else if(z<=1.2) rate0=0.908981223505+(-0.0304856447684)*(z-1.15)/0.05;
else if(z<=1.25) rate0=0.878495578737+(-0.0262314108369)*(z-1.2)/0.05;
else if(z<=1.3) rate0=0.8522641679+(-0.0143201343071)*(z-1.25)/0.05;
else if(z<=1.35) rate0=0.837944033593+(0)*(z-1.3)/0.05;
else if(z<=1.4) rate0=0.837944033593+(0)*(z-1.35)/0.05;
else if(z<=1.45) rate0=0.837944033593+(0)*(z-1.4)/0.05;
else if(z<=1.5) rate0=0.837944033593+(0)*(z-1.45)/0.05;
else if(z<=1.55) rate0=0.837944033593+(0)*(z-1.5)/0.05;
else if(z<=1.6) rate0=0.837944033593+(0)*(z-1.55)/0.05;
else rate0=0.837944033593;
end
endfunction
analog function real rate1;
input z; real z;
begin
if(z<=0.2) rate1=2.56512955264;
else if(z<=0.25) rate1=2.56512955264+(0)*(z-0.2)/0.05;
else if(z<=0.3) rate1=2.56512955264+(-0.043797562897)*(z-0.25)/0.05;
else if(z<=0.35) rate1=2.52133198974+(-0.134774974331)*(z-0.3)/0.05;
else if(z<=0.4) rate1=2.38655701541+(-0.142119338552)*(z-0.35)/0.05;
else if(z<=0.45) rate1=2.24443767686+(-0.134025806662)*(z-0.4)/0.05;
else if(z<=0.5) rate1=2.1104118702+(-0.127318024155)*(z-0.45)/0.05;
else if(z<=0.55) rate1=1.98309384604+(-0.12267047724)*(z-0.5)/0.05;
else if(z<=0.6) rate1=1.8604233688+(-0.121033808093)*(z-0.55)/0.05;
else if(z<=0.65) rate1=1.73938956071+(-0.122402948986)*(z-0.6)/0.05;
else if(z<=0.7) rate1=1.61698661172+(-0.122111881334)*(z-0.65)/0.05;
else if(z<=0.75) rate1=1.49487473039+(-0.116665220926)*(z-0.7)/0.05;
else if(z<=0.8) rate1=1.37820950946+(-0.105660943523)*(z-0.75)/0.05;
else if(z<=0.85) rate1=1.27254856594+(-0.0940593641387)*(z-0.8)/0.05;
else if(z<=0.9) rate1=1.1784892018+(-0.0824312170361)*(z-0.85)/0.05;
else if(z<=0.95) rate1=1.09605798477+(-0.0718849232528)*(z-0.9)/0.05;
else if(z<=1) rate1=1.02417306151+(-0.0623986501015)*(z-0.95)/0.05;
else if(z<=1.05) rate1=0.961774411411+(-0.0531705617231)*(z-1)/0.05;
else if(z<=1.1) rate1=0.908603849688+(-0.0443392427082)*(z-1.05)/0.05;
else if(z<=1.15) rate1=0.86426460698+(-0.0364065798384)*(z-1.1)/0.05;
else if(z<=1.2) rate1=0.827858027142+(-0.0291282773961)*(z-1.15)/0.05;
else if(z<=1.25) rate1=0.798729749746+(-0.0240560787921)*(z-1.2)/0.05;
else if(z<=1.3) rate1=0.774673670954+(-0.0199945157629)*(z-1.25)/0.05;
else if(z<=1.35) rate1=0.754679155191+(-0.0103195447465)*(z-1.3)/0.05;
else if(z<=1.4) rate1=0.744359610444+(0)*(z-1.35)/0.05;
else if(z<=1.45) rate1=0.744359610444+(0)*(z-1.4)/0.05;
else if(z<=1.5) rate1=0.744359610444+(0)*(z-1.45)/0.05;
else if(z<=1.55) rate1=0.744359610444+(0)*(z-1.5)/0.05;
else if(z<=1.6) rate1=0.744359610444+(0)*(z-1.55)/0.05;
else rate1=0.744359610444;
end
endfunction
analog function real rate2;
input z; real z;
begin
if(z<=0.2) rate2=1.999210635;
else if(z<=0.25) rate2=1.999210635+(0)*(z-0.2)/0.05;
else if(z<=0.3) rate2=1.999210635+(0)*(z-0.25)/0.05;
else if(z<=0.35) rate2=1.999210635+(-0.00383455113039)*(z-0.3)/0.05;
else if(z<=0.4) rate2=1.99537608386+(-0.0471413948032)*(z-0.35)/0.05;
else if(z<=0.45) rate2=1.94823468906+(-0.0619433958658)*(z-0.4)/0.05;
else if(z<=0.5) rate2=1.8862912932+(-0.0806315430285)*(z-0.45)/0.05;
else if(z<=0.55) rate2=1.80565975017+(-0.126257852511)*(z-0.5)/0.05;
else if(z<=0.6) rate2=1.67940189766+(-0.127128499451)*(z-0.55)/0.05;
else if(z<=0.65) rate2=1.55227339821+(-0.11965159779)*(z-0.6)/0.05;
else if(z<=0.7) rate2=1.43262180042+(-0.11385363109)*(z-0.65)/0.05;
else if(z<=0.75) rate2=1.31876816933+(-0.110508557621)*(z-0.7)/0.05;
else if(z<=0.8) rate2=1.20825961171+(-0.108757934968)*(z-0.75)/0.05;
else if(z<=0.85) rate2=1.09950167674+(-0.103765732427)*(z-0.8)/0.05;
else if(z<=0.9) rate2=0.995735944311+(-0.0932402273204)*(z-0.85)/0.05;
else if(z<=0.95) rate2=0.902495716991+(-0.0800497831549)*(z-0.9)/0.05;
else if(z<=1) rate2=0.822445933836+(-0.0669359767492)*(z-0.95)/0.05;
else if(z<=1.05) rate2=0.755509957087+(-0.0548580307511)*(z-1)/0.05;
else if(z<=1.1) rate2=0.700651926335+(-0.0431686460968)*(z-1.05)/0.05;
else if(z<=1.15) rate2=0.657483280239+(-0.0329533903344)*(z-1.1)/0.05;
else if(z<=1.2) rate2=0.624529889904+(-0.0243961157204)*(z-1.15)/0.05;
else if(z<=1.25) rate2=0.600133774184+(-0.0177531889022)*(z-1.2)/0.05;
else if(z<=1.3) rate2=0.582380585282+(-0.012233259728)*(z-1.25)/0.05;
else if(z<=1.35) rate2=0.570147325554+(-0.00839112034475)*(z-1.3)/0.05;
else if(z<=1.4) rate2=0.561756205209+(-0.00664015428076)*(z-1.35)/0.05;
else if(z<=1.45) rate2=0.555116050928+(-0.00200193738125)*(z-1.4)/0.05;
else if(z<=1.5) rate2=0.553114113547+(0)*(z-1.45)/0.05;
else if(z<=1.55) rate2=0.553114113547+(0)*(z-1.5)/0.05;
else if(z<=1.6) rate2=0.553114113547+(0)*(z-1.55)/0.05;
else rate2=0.553114113547;
end
endfunction
analog function real rate3;
input z; real z;
begin
if(z<=0.2) rate3=1.74186949585;
else if(z<=0.25) rate3=1.74186949585+(0)*(z-0.2)/0.05;
else if(z<=0.3) rate3=1.74186949585+(0)*(z-0.25)/0.05;
else if(z<=0.35) rate3=1.74186949585+(0)*(z-0.3)/0.05;
else if(z<=0.4) rate3=1.74186949585+(-0.0243831344311)*(z-0.35)/0.05;
else if(z<=0.45) rate3=1.71748636142+(-0.0602816648803)*(z-0.4)/0.05;
else if(z<=0.5) rate3=1.65720469654+(-0.0709235064804)*(z-0.45)/0.05;
else if(z<=0.55) rate3=1.58628119005+(-0.0780910261371)*(z-0.5)/0.05;
else if(z<=0.6) rate3=1.50819016392+(-0.0926478582971)*(z-0.55)/0.05;
else if(z<=0.65) rate3=1.41554230562+(-0.119623498227)*(z-0.6)/0.05;
else if(z<=0.7) rate3=1.29591880739+(-0.116668093914)*(z-0.65)/0.05;
else if(z<=0.75) rate3=1.17925071348+(-0.10974418963)*(z-0.7)/0.05;
else if(z<=0.8) rate3=1.06950652385+(-0.104501537267)*(z-0.75)/0.05;
else if(z<=0.85) rate3=0.965004986583+(-0.100621441785)*(z-0.8)/0.05;
else if(z<=0.9) rate3=0.864383544798+(-0.0939852967218)*(z-0.85)/0.05;
else if(z<=0.95) rate3=0.770398248077+(-0.0819638629276)*(z-0.9)/0.05;
else if(z<=1) rate3=0.688434385149+(-0.0674942826558)*(z-0.95)/0.05;
else if(z<=1.05) rate3=0.620940102493+(-0.0532126515721)*(z-1)/0.05;
else if(z<=1.1) rate3=0.567727450921+(-0.0399788621761)*(z-1.05)/0.05;
else if(z<=1.15) rate3=0.527748588745+(-0.0285820695035)*(z-1.1)/0.05;
else if(z<=1.2) rate3=0.499166519242+(-0.0194434481712)*(z-1.15)/0.05;
else if(z<=1.25) rate3=0.47972307107+(-0.0123307446401)*(z-1.2)/0.05;
else if(z<=1.3) rate3=0.46739232643+(-0.0069433984777)*(z-1.25)/0.05;
else if(z<=1.35) rate3=0.460448927953+(-0.00282977644943)*(z-1.3)/0.05;
else if(z<=1.4) rate3=0.457619151503+(5.37627325303e-05)*(z-1.35)/0.05;
else if(z<=1.45) rate3=0.457672914236+(0.000231372073052)*(z-1.4)/0.05;
else if(z<=1.5) rate3=0.457904286309+(-1.91061397293e-05)*(z-1.45)/0.05;
else if(z<=1.55) rate3=0.457885180169+(0)*(z-1.5)/0.05;
else if(z<=1.6) rate3=0.457885180169+(0)*(z-1.55)/0.05;
else rate3=0.457885180169;
end
endfunction
analog function real rate4;
input z; real z;
begin
if(z<=0.2) rate4=1.05623957094;
else if(z<=0.25) rate4=1.05623957094+(0)*(z-0.2)/0.05;
else if(z<=0.3) rate4=1.05623957094+(0)*(z-0.25)/0.05;
else if(z<=0.35) rate4=1.05623957094+(0)*(z-0.3)/0.05;
else if(z<=0.4) rate4=1.05623957094+(0)*(z-0.35)/0.05;
else if(z<=0.45) rate4=1.05623957094+(-0.0418469731097)*(z-0.4)/0.05;
else if(z<=0.5) rate4=1.01439259783+(-0.0604784364055)*(z-0.45)/0.05;
else if(z<=0.55) rate4=0.953914161427+(-0.0692958544093)*(z-0.5)/0.05;
else if(z<=0.6) rate4=0.884618307018+(-0.0775172564795)*(z-0.55)/0.05;
else if(z<=0.65) rate4=0.807101050538+(-0.0859071655323)*(z-0.6)/0.05;
else if(z<=0.7) rate4=0.721193885006+(-0.0944299893166)*(z-0.65)/0.05;
else if(z<=0.75) rate4=0.626763895689+(-0.101978313953)*(z-0.7)/0.05;
else if(z<=0.8) rate4=0.524785581736+(-0.106443410371)*(z-0.75)/0.05;
else if(z<=0.85) rate4=0.418342171365+(-0.104419253267)*(z-0.8)/0.05;
else if(z<=0.9) rate4=0.313922918098+(-0.0457961709504)*(z-0.85)/0.05;
else if(z<=0.95) rate4=0.268126747148+(-0.0296341989007)*(z-0.9)/0.05;
else if(z<=1) rate4=0.238492548247+(-0.0296341989007)*(z-0.95)/0.05;
else if(z<=1.05) rate4=0.208858349347+(-0.0296341989007)*(z-1)/0.05;
else if(z<=1.1) rate4=0.179224150446+(-0.0296341989007)*(z-1.05)/0.05;
else if(z<=1.15) rate4=0.149589951545+(-0.0296341989007)*(z-1.1)/0.05;
else if(z<=1.2) rate4=0.119955752645+(0.00256656009909)*(z-1.15)/0.05;
else if(z<=1.25) rate4=0.122522312744+(0.0185151373752)*(z-1.2)/0.05;
else if(z<=1.3) rate4=0.141037450119+(0.0204672781724)*(z-1.25)/0.05;
else if(z<=1.35) rate4=0.161504728291+(0.0214794624166)*(z-1.3)/0.05;
else if(z<=1.4) rate4=0.182984190708+(0.0219523809189)*(z-1.35)/0.05;
else if(z<=1.45) rate4=0.204936571627+(0.0221003614312)*(z-1.4)/0.05;
else if(z<=1.5) rate4=0.227036933058+(0.0219526505904)*(z-1.45)/0.05;
else if(z<=1.55) rate4=0.248989583648+(0.00737707641569)*(z-1.5)/0.05;
else if(z<=1.6) rate4=0.256366660064+(0)*(z-1.55)/0.05;
else rate4=0.256366660064;
end
endfunction
analog function real rate5;
input z; real z;
begin
if(z<=0.2) rate5=0.794428934686;
else if(z<=0.25) rate5=0.794428934686+(0)*(z-0.2)/0.05;
else if(z<=0.3) rate5=0.794428934686+(0)*(z-0.25)/0.05;
else if(z<=0.35) rate5=0.794428934686+(0)*(z-0.3)/0.05;
else if(z<=0.4) rate5=0.794428934686+(0)*(z-0.35)/0.05;
else if(z<=0.45) rate5=0.794428934686+(-0.034518077287)*(z-0.4)/0.05;
else if(z<=0.5) rate5=0.759910857399+(-0.0614821625287)*(z-0.45)/0.05;
else if(z<=0.55) rate5=0.698428694871+(-0.0680212067952)*(z-0.5)/0.05;
else if(z<=0.6) rate5=0.630407488075+(-0.0735569997095)*(z-0.55)/0.05;
else if(z<=0.65) rate5=0.556850488366+(-0.0784091771098)*(z-0.6)/0.05;
else if(z<=0.7) rate5=0.478441311256+(-0.082529653402)*(z-0.65)/0.05;
else if(z<=0.75) rate5=0.395911657854+(-0.0848163519645)*(z-0.7)/0.05;
else if(z<=0.8) rate5=0.31109530589+(-0.0830294716634)*(z-0.75)/0.05;
else if(z<=0.85) rate5=0.228065834226+(-0.0736495264857)*(z-0.8)/0.05;
else if(z<=0.9) rate5=0.154416307741+(-0.0540830946488)*(z-0.85)/0.05;
else if(z<=0.95) rate5=0.100333213092+(-0.000536807659719)*(z-0.9)/0.05;
else if(z<=1) rate5=0.0997964054322+(0.0103245096397)*(z-0.95)/0.05;
else if(z<=1.05) rate5=0.110120915072+(0.0103245096397)*(z-1)/0.05;
else if(z<=1.1) rate5=0.120445424712+(0.0103245096397)*(z-1.05)/0.05;
else if(z<=1.15) rate5=0.130769934351+(0.0103245096397)*(z-1.1)/0.05;
else if(z<=1.2) rate5=0.141094443991+(0.0103245096397)*(z-1.15)/0.05;
else if(z<=1.25) rate5=0.151418953631+(0.0144176687297)*(z-1.2)/0.05;
else if(z<=1.3) rate5=0.165836622361+(0.0270547287727)*(z-1.25)/0.05;
else if(z<=1.35) rate5=0.192891351133+(0.0264559004894)*(z-1.3)/0.05;
else if(z<=1.4) rate5=0.219347251623+(0.0257611243094)*(z-1.35)/0.05;
else if(z<=1.45) rate5=0.245108375932+(0.0250384936454)*(z-1.4)/0.05;
else if(z<=1.5) rate5=0.270146869577+(0.0243123891657)*(z-1.45)/0.05;
else if(z<=1.55) rate5=0.294459258743+(0.0133455470958)*(z-1.5)/0.05;
else if(z<=1.6) rate5=0.307804805839+(0)*(z-1.55)/0.05;
else rate5=0.307804805839;
end
endfunction
analog function real rate6;
input z; real z;
begin
if(z<=0.2) rate6=0.719910789413;
else if(z<=0.25) rate6=0.719910789413+(0)*(z-0.2)/0.05;
else if(z<=0.3) rate6=0.719910789413+(0)*(z-0.25)/0.05;
else if(z<=0.35) rate6=0.719910789413+(0)*(z-0.3)/0.05;
else if(z<=0.4) rate6=0.719910789413+(0)*(z-0.35)/0.05;
else if(z<=0.45) rate6=0.719910789413+(-0.0237219560575)*(z-0.4)/0.05;
else if(z<=0.5) rate6=0.696188833356+(-0.0577288158738)*(z-0.45)/0.05;
else if(z<=0.55) rate6=0.638460017482+(-0.0636005967749)*(z-0.5)/0.05;
else if(z<=0.6) rate6=0.574859420707+(-0.0676984223771)*(z-0.55)/0.05;
else if(z<=0.65) rate6=0.50716099833+(-0.0709684350783)*(z-0.6)/0.05;
else if(z<=0.7) rate6=0.436192563252+(-0.0731302268039)*(z-0.65)/0.05;
else if(z<=0.75) rate6=0.363062336448+(-0.0730981127393)*(z-0.7)/0.05;
else if(z<=0.8) rate6=0.289964223709+(-0.0689838179108)*(z-0.75)/0.05;
else if(z<=0.85) rate6=0.220980405798+(-0.0580871264668)*(z-0.8)/0.05;
else if(z<=0.9) rate6=0.162893279331+(-0.0390825667804)*(z-0.85)/0.05;
else if(z<=0.95) rate6=0.123810712551+(-0.0161135283682)*(z-0.9)/0.05;
else if(z<=1) rate6=0.107697184182+(0.0146712002737)*(z-0.95)/0.05;
else if(z<=1.05) rate6=0.122368384456+(0.0175850392639)*(z-1)/0.05;
else if(z<=1.1) rate6=0.13995342372+(0.0175850392639)*(z-1.05)/0.05;
else if(z<=1.15) rate6=0.157538462984+(0.0175850392639)*(z-1.1)/0.05;
else if(z<=1.2) rate6=0.175123502248+(0.0175850392639)*(z-1.15)/0.05;
else if(z<=1.25) rate6=0.192708541511+(0.0175850392639)*(z-1.2)/0.05;
else if(z<=1.3) rate6=0.210293580775+(0.0215014262013)*(z-1.25)/0.05;
else if(z<=1.35) rate6=0.231795006977+(0.0271650899857)*(z-1.3)/0.05;
else if(z<=1.4) rate6=0.258960096962+(0.026209537874)*(z-1.35)/0.05;
else if(z<=1.45) rate6=0.285169634836+(0.0253012102846)*(z-1.4)/0.05;
else if(z<=1.5) rate6=0.310470845121+(0.0244352871078)*(z-1.45)/0.05;
else if(z<=1.55) rate6=0.334906132229+(0.016887144765)*(z-1.5)/0.05;
else if(z<=1.6) rate6=0.351793276994+(0)*(z-1.55)/0.05;
else rate6=0.351793276994;
end
endfunction
analog function real rate7;
input z; real z;
begin
if(z<=0.2) rate7=0.635736660967;
else if(z<=0.25) rate7=0.635736660967+(0)*(z-0.2)/0.05;
else if(z<=0.3) rate7=0.635736660967+(0)*(z-0.25)/0.05;
else if(z<=0.35) rate7=0.635736660967+(0)*(z-0.3)/0.05;
else if(z<=0.4) rate7=0.635736660967+(0)*(z-0.35)/0.05;
else if(z<=0.45) rate7=0.635736660967+(0)*(z-0.4)/0.05;
else if(z<=0.5) rate7=0.635736660967+(-0.0417627151564)*(z-0.45)/0.05;
else if(z<=0.55) rate7=0.593973945811+(-0.0528194026551)*(z-0.5)/0.05;
else if(z<=0.6) rate7=0.541154543155+(-0.0555676860904)*(z-0.55)/0.05;
else if(z<=0.65) rate7=0.485586857065+(-0.0569157540403)*(z-0.6)/0.05;
else if(z<=0.7) rate7=0.428671103025+(-0.0567999110268)*(z-0.65)/0.05;
else if(z<=0.75) rate7=0.371871191998+(-0.0545876844321)*(z-0.7)/0.05;
else if(z<=0.8) rate7=0.317283507566+(-0.0490255221319)*(z-0.75)/0.05;
else if(z<=0.85) rate7=0.268257985434+(-0.0383827003683)*(z-0.8)/0.05;
else if(z<=0.9) rate7=0.229875285066+(-0.022477008359)*(z-0.85)/0.05;
else if(z<=0.95) rate7=0.207398276707+(-0.00486365143114)*(z-0.9)/0.05;
else if(z<=1) rate7=0.202534625276+(0.00855053090247)*(z-0.95)/0.05;
else if(z<=1.05) rate7=0.211085156178+(0.0156483127849)*(z-1)/0.05;
else if(z<=1.1) rate7=0.226733468963+(0.0185959572905)*(z-1.05)/0.05;
else if(z<=1.15) rate7=0.245329426253+(0.0197078647181)*(z-1.1)/0.05;
else if(z<=1.2) rate7=0.265037290972+(0.0207166732317)*(z-1.15)/0.05;
else if(z<=1.25) rate7=0.285753964203+(0.0212127317952)*(z-1.2)/0.05;
else if(z<=1.3) rate7=0.306966695998+(0.0212127317952)*(z-1.25)/0.05;
else if(z<=1.35) rate7=0.328179427794+(0.0212127317952)*(z-1.3)/0.05;
else if(z<=1.4) rate7=0.349392159589+(0.0212127317952)*(z-1.35)/0.05;
else if(z<=1.45) rate7=0.370604891384+(0.0239336794551)*(z-1.4)/0.05;
else if(z<=1.5) rate7=0.394538570839+(0.024686089768)*(z-1.45)/0.05;
else if(z<=1.55) rate7=0.419224660607+(0.0236404233903)*(z-1.5)/0.05;
else if(z<=1.6) rate7=0.442865083997+(0.00492499850495)*(z-1.55)/0.05;
else rate7=0.447790082502;
end
endfunction
analog function real rate8;
input z; real z;
begin
if(z<=0.2) rate8=0.613211164049;
else if(z<=0.25) rate8=0.613211164049+(0)*(z-0.2)/0.05;
else if(z<=0.3) rate8=0.613211164049+(0)*(z-0.25)/0.05;
else if(z<=0.35) rate8=0.613211164049+(0)*(z-0.3)/0.05;
else if(z<=0.4) rate8=0.613211164049+(0)*(z-0.35)/0.05;
else if(z<=0.45) rate8=0.613211164049+(0)*(z-0.4)/0.05;
else if(z<=0.5) rate8=0.613211164049+(-0.0206643664377)*(z-0.45)/0.05;
else if(z<=0.55) rate8=0.592546797611+(-0.0476870634845)*(z-0.5)/0.05;
else if(z<=0.6) rate8=0.544859734127+(-0.0502398654453)*(z-0.55)/0.05;
else if(z<=0.65) rate8=0.494619868682+(-0.0511397033171)*(z-0.6)/0.05;
else if(z<=0.7) rate8=0.443480165365+(-0.0505534381713)*(z-0.65)/0.05;
else if(z<=0.75) rate8=0.392926727193+(-0.0479167220277)*(z-0.7)/0.05;
else if(z<=0.8) rate8=0.345010005166+(-0.0423563269848)*(z-0.75)/0.05;
else if(z<=0.85) rate8=0.302653678181+(-0.0324379067762)*(z-0.8)/0.05;
else if(z<=0.9) rate8=0.270215771405+(-0.0179519944441)*(z-0.85)/0.05;
else if(z<=0.95) rate8=0.25226377696+(-0.00223428397205)*(z-0.9)/0.05;
else if(z<=1) rate8=0.250029492988+(0.0097541337395)*(z-0.95)/0.05;
else if(z<=1.05) rate8=0.259783626728+(0.0161538596028)*(z-1)/0.05;
else if(z<=1.1) rate8=0.275937486331+(0.0188852361947)*(z-1.05)/0.05;
else if(z<=1.15) rate8=0.294822722525+(0.0199507272646)*(z-1.1)/0.05;
else if(z<=1.2) rate8=0.31477344979+(0.0203889004143)*(z-1.15)/0.05;
else if(z<=1.25) rate8=0.335162350204+(0.0206365721955)*(z-1.2)/0.05;
else if(z<=1.3) rate8=0.3557989224+(0.0208398313415)*(z-1.25)/0.05;
else if(z<=1.35) rate8=0.376638753741+(0.0214308016689)*(z-1.3)/0.05;
else if(z<=1.4) rate8=0.39806955541+(0.0217122942154)*(z-1.35)/0.05;
else if(z<=1.45) rate8=0.419781849626+(0.0217122942154)*(z-1.4)/0.05;
else if(z<=1.5) rate8=0.441494143841+(0.0217122942154)*(z-1.45)/0.05;
else if(z<=1.55) rate8=0.463206438056+(0.0229509484153)*(z-1.5)/0.05;
else if(z<=1.6) rate8=0.486157386472+(0.0130175456655)*(z-1.55)/0.05;
else rate8=0.499174932137;
end
endfunction
analog function real rate9;
input z; real z;
begin
if(z<=0.2) rate9=0.598891173952;
else if(z<=0.25) rate9=0.598891173952+(0)*(z-0.2)/0.05;
else if(z<=0.3) rate9=0.598891173952+(0)*(z-0.25)/0.05;
else if(z<=0.35) rate9=0.598891173952+(0)*(z-0.3)/0.05;
else if(z<=0.4) rate9=0.598891173952+(0)*(z-0.35)/0.05;
else if(z<=0.45) rate9=0.598891173952+(0)*(z-0.4)/0.05;
else if(z<=0.5) rate9=0.598891173952+(-0.000149358954367)*(z-0.45)/0.05;
else if(z<=0.55) rate9=0.598741814998+(-0.0429343160198)*(z-0.5)/0.05;
else if(z<=0.6) rate9=0.555807498978+(-0.0453800613178)*(z-0.55)/0.05;
else if(z<=0.65) rate9=0.51042743766+(-0.0461389752038)*(z-0.6)/0.05;
else if(z<=0.7) rate9=0.464288462456+(-0.0453414367796)*(z-0.65)/0.05;
else if(z<=0.75) rate9=0.418947025677+(-0.042581811226)*(z-0.7)/0.05;
else if(z<=0.8) rate9=0.376365214451+(-0.0371163574998)*(z-0.75)/0.05;
else if(z<=0.85) rate9=0.339248856951+(-0.0279377537403)*(z-0.8)/0.05;
else if(z<=0.9) rate9=0.311311103211+(-0.0148584485008)*(z-0.85)/0.05;
else if(z<=0.95) rate9=0.29645265471+(-0.000567503313781)*(z-0.9)/0.05;
else if(z<=1) rate9=0.295885151396+(0.0103645467808)*(z-0.95)/0.05;
else if(z<=1.05) rate9=0.306249698177+(0.0162965138558)*(z-1)/0.05;
else if(z<=1.1) rate9=0.322546212033+(0.0189010328754)*(z-1.05)/0.05;
else if(z<=1.15) rate9=0.341447244908+(0.0199573576862)*(z-1.1)/0.05;
else if(z<=1.2) rate9=0.361404602594+(0.020402041091)*(z-1.15)/0.05;
else if(z<=1.25) rate9=0.381806643685+(0.0206363004137)*(z-1.2)/0.05;
else if(z<=1.3) rate9=0.402442944099+(0.0208163644495)*(z-1.25)/0.05;
else if(z<=1.35) rate9=0.423259308548+(0.0209939858809)*(z-1.3)/0.05;
else if(z<=1.4) rate9=0.444253294429+(0.0211742312465)*(z-1.35)/0.05;
else if(z<=1.45) rate9=0.465427525676+(0.0213549918377)*(z-1.4)/0.05;
else if(z<=1.5) rate9=0.486782517513+(0.00689123958044)*(z-1.45)/0.05;
else if(z<=1.55) rate9=0.493673757094+(0)*(z-1.5)/0.05;
else if(z<=1.6) rate9=0.493673757094+(0)*(z-1.55)/0.05;
else rate9=0.493673757094;
end
endfunction
analog begin
@(initial_step) vinit=V(vin);
if(V(vin)<=0.2) rate=rate0(V(vhold));
else if(V(vin)<=0.3) rate=rate0(V(vhold))+(rate1(V(vhold))-rate0(V(vhold)))*(V(vin)-0.2)/0.1;
else if(V(vin)<=0.5) rate=rate1(V(vhold))+(rate2(V(vhold))-rate1(V(vhold)))*(V(vin)-0.3)/0.2;
else if(V(vin)<=0.6) rate=rate2(V(vhold))+(rate3(V(vhold))-rate2(V(vhold)))*(V(vin)-0.5)/0.1;
else if(V(vin)<=0.9) rate=rate3(V(vhold))+(rate4(V(vhold))-rate3(V(vhold)))*(V(vin)-0.6)/0.3;
else if(V(vin)<=1.1) rate=rate4(V(vhold))+(rate5(V(vhold))-rate4(V(vhold)))*(V(vin)-0.9)/0.2;
else if(V(vin)<=1.2) rate=rate5(V(vhold))+(rate6(V(vhold))-rate5(V(vhold)))*(V(vin)-1.1)/0.1;
else if(V(vin)<=1.4) rate=rate6(V(vhold))+(rate7(V(vhold))-rate6(V(vhold)))*(V(vin)-1.2)/0.2;
else if(V(vin)<=1.5) rate=rate7(V(vhold))+(rate8(V(vhold))-rate7(V(vhold)))*(V(vin)-1.4)/0.1;
else if(V(vin)<=1.6) rate=rate8(V(vhold))+(rate9(V(vhold))-rate8(V(vhold)))*(V(vin)-1.5)/0.1;
else rate=rate9(V(vhold));
gate=transition(V(clock)<0.9 ? 1.0 : 0.0,65p,35p,35p);
V(vhold) <+ idt(gate*(V(vin)-V(vhold))*rate*1e9,0.0,V(clock)>0.9 ? 1 : 0);
$bound_step(10p);
end
endmodule
