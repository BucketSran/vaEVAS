`include "disciplines.vams"
module window_comparator_ref(VDD,VSS,vin,out);
inout VDD,VSS;input vin;output out;electrical VDD,VSS,vin,out;
parameter real vlow=0.3,vhigh=0.6,tedge=200p,tick=500p;
integer lower_ok,upper_ok;
analog begin
 @(initial_step)begin lower_ok=(V(vin,VSS)>vlow);upper_ok=(V(vin,VSS)<vhigh);end
 @(timer(0,tick))begin lower_ok=(V(vin,VSS)>vlow);upper_ok=(V(vin,VSS)<vhigh);end
 V(out,VSS)<+transition(lower_ok && upper_ok,0,tedge,tedge)*V(VDD,VSS);
end
endmodule
