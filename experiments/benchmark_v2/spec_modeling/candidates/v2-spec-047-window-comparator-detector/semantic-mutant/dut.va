`include "disciplines.vams"
module window_comparator_ref(VDD,VSS,vin,out);
inout VDD,VSS;input vin;output out;electrical VDD,VSS,vin,out;
parameter real vlow=0.3,vhigh=0.6,tedge=200p,tick=500p;
integer state;
analog begin
 @(initial_step)state=(V(vin,VSS)>vlow && V(vin,VSS)<vhigh+0.1);
 @(timer(0,tick))state=(V(vin,VSS)>vlow && V(vin,VSS)<vhigh+0.1);
 V(out,VSS)<+transition(state,0,tedge,tedge)*V(VDD,VSS);
end
endmodule
