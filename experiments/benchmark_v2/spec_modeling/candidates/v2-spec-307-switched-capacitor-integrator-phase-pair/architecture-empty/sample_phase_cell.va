`include "constants.vams"
`include "disciplines.vams"

module sample_phase_cell(vin, phi1, phi2, rst, enable, sample_node, sample_valid);
    input vin, phi1, phi2, rst, enable;
    output sample_node, sample_valid;
    electrical vin, phi1, phi2, rst, enable, sample_node, sample_valid;

    parameter real vdd = 0.9;
    parameter real vss = 0.0;
    parameter real vcm = 0.45;
    parameter real vth = 0.45;
    parameter real tr = 200p from (0:inf);
    real sample_v, valid_v;

    analog function real clip01;
        input x;
        real x;
        begin
            if (x < vss) clip01 = vss;
            else if (x > vdd) clip01 = vdd;
            else clip01 = x;
        end
    endfunction

    analog begin
 V(sample_node) <+ 0.45;
 V(sample_valid) <+ 0.0;
end
endmodule
