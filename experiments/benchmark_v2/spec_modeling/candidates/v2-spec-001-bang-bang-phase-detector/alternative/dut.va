`include "disciplines.vams"
module alexander(data,clk,rst,enable,retimed,up,down);
input data,clk,rst,enable; output retimed,up,down;
electrical data,clk,rst,enable,retimed,up,down;
parameter real vdd=0.9,vth=0.45,trf=10p,td=0;
integer samples,u,d;
analog begin
 @(initial_step) begin samples=0;u=0;d=0;end
 @(cross(V(rst)-vth,+1) or cross(V(enable)-vth,-1)) begin samples=0;u=0;d=0;end
 @(cross(V(clk)-vth,-1)) begin if(V(rst)<=vth && V(enable)>vth)samples=(samples & 5) | ((V(data)>vth)<<1);end
 @(cross(V(clk)-vth,+1)) begin
  if(V(rst)>vth || V(enable)<=vth)begin samples=0;u=0;d=0;end
  else begin samples=((samples & 1)<<2) | (samples & 2) | (V(data)>vth);u=(samples==3 || samples==4);d=(samples==1 || samples==6);end
 end
 V(retimed)<+transition((samples & 1)?vdd:0,td,trf,trf);
 V(up)<+transition(u?vdd:0,td,trf,trf);V(down)<+transition(d?vdd:0,td,trf,trf);
end
endmodule
