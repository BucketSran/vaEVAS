`include "constants.vams"
`include "disciplines.vams"

module programmable_gain_amplifier(clk, rst, gain_sel, vin, out, metric);
    input clk, rst, gain_sel, vin;
    output out, metric;
    electrical clk, rst, gain_sel, vin, out, metric;

    parameter real vth = 0.45;
    parameter real vcm = 0.45;
    parameter real gain_low = 0.8;
    parameter real gain_high = 2.4;
    parameter real vmin = 0.0;
    parameter real vmax = 0.9;
    parameter real tr = 200p from (0:inf);

    integer gain_mode;
    real gain_value;
    real raw;
    real bounded;
    real clipped;

    analog begin
        @(initial_step) begin
            gain_mode = 0;
        end

        @(cross(V(clk) - vth, +1)) begin
            if (V(rst) > vth)
                gain_mode = 0;
            else if (V(gain_sel) > vth)
                gain_mode = 2;
            else
                gain_mode = 1;
        end

        gain_value = gain_mode==0 ? 1.0 : (gain_mode==1 ? gain_low : gain_high);
        raw = vcm + gain_value * (V(vin) - vcm);
        bounded = raw;
        clipped = 0.0;
        if (bounded > vmax) begin
            bounded = vmax;
            clipped = 1.0;
        end
        if (bounded < vmin) begin
            bounded = vmin;
            clipped = 1.0;
        end
        if (V(rst) > vth) begin
            bounded = vcm;
            clipped = 0.0;
        end

        V(out) <+ bounded;
        V(metric) <+ transition((clipped > 0.5) ? 0.9 : 0.0, 0, tr, tr);
    end
endmodule
