`include "constants.vams"
`include "disciplines.vams"

module chopper_stabilized_differential_amplifier(
    vinp, vinn, chop_clk, rst, enable, hold,
    voutp, voutn, settled, offset_residual
);
input vinp, vinn, chop_clk, rst, enable, hold;
output voutp, voutn, settled, offset_residual;
electrical vinp, vinn, chop_clk, rst, enable, hold;
electrical voutp, voutn, settled, offset_residual;
electrical demod_sample_i, baseband_ref_i, event_strobe_i;

electrical unused_voutp,unused_voutn,unused_settled,unused_offset_residual,unused_demod_sample_i,unused_baseband_ref_i,unused_event_strobe_i;
parameter real vdd=0.9, vss=0.0, vcm=0.45, vth=0.45;
parameter real gain=3.0, vos_amp=20m, lp_alpha=0.25;
parameter real settle_tol=20m, tr=100p;
parameter integer settle_cycles=3;

private_chopper_gain_core #(.vdd(vdd), .vss(vss), .vth(vth), .gain(gain), .vos_amp(vos_amp), .tr(tr))
    ICHOP (vinp, vinn, chop_clk, rst, enable, hold, demod_sample_i, baseband_ref_i, event_strobe_i);
private_synchronous_lp_state #(.vdd(vdd), .vss(vss), .vcm(vcm), .vth(vth), .gain(gain), .lp_alpha(lp_alpha), .settle_tol(settle_tol), .settle_cycles(settle_cycles), .tr(tr))
    ILP (demod_sample_i, baseband_ref_i, event_strobe_i, rst, enable, hold, voutp, voutn, settled, offset_residual);
chopper_gain_core #(.vdd(vdd), .vss(vss), .vth(vth), .gain(gain), .vos_amp(vos_amp), .tr(tr))
    UNUSED_ICHOP (vinp, vinn, chop_clk, rst, enable, hold, unused_demod_sample_i, unused_baseband_ref_i, unused_event_strobe_i);
synchronous_lp_state #(.vdd(vdd), .vss(vss), .vcm(vcm), .vth(vth), .gain(gain), .lp_alpha(lp_alpha), .settle_tol(settle_tol), .settle_cycles(settle_cycles), .tr(tr))
    UNUSED_ILP (unused_demod_sample_i, unused_baseband_ref_i, unused_event_strobe_i, rst, enable, hold, unused_voutp, unused_voutn, unused_settled, unused_offset_residual);

endmodule
`include "constants.vams"
`include "disciplines.vams"
module private_chopper_gain_core(vinp,vinn,chop_clk,rst,enable,hold,demod_sample,baseband_ref,event_strobe);
input vinp,vinn,chop_clk,rst,enable,hold; output demod_sample,baseband_ref,event_strobe;
electrical vinp,vinn,chop_clk,rst,enable,hold,demod_sample,baseband_ref,event_strobe;
parameter real vdd=0.9,vss=0.0,vth=0.45,gain=3.0,vos_amp=20m,tr=100p;
real sample_q,ref_q,strobe_q,input_diff,chopped,amplified; integer polarity;
analog begin
 @(initial_step) begin sample_q=0.0; ref_q=0.0; strobe_q=vss; end
 @(cross(V(chop_clk)-vth,+1) or cross(V(chop_clk)-vth,-1)) begin
  if((V(rst)>vth)||(V(enable)<=vth)) sample_q=0.0;
  else if(V(hold)<=vth) begin polarity=(V(chop_clk)>vth)?1:-1; input_diff=V(vinp)-V(vinn); chopped=polarity*input_diff; amplified=gain*(chopped+vos_amp); sample_q=polarity*amplified; ref_q=gain*input_diff; strobe_q=(strobe_q>vth)?vss:vdd; end
 end
 @(cross(V(rst)-vth,+1) or cross(V(enable)-vth,-1)) begin sample_q=0.0; ref_q=0.0; strobe_q=vss; end
 V(demod_sample)<+sample_q; V(baseband_ref)<+ref_q; V(event_strobe)<+transition(strobe_q,2.0*tr,tr,tr);
end
endmodule
`include "constants.vams"
`include "disciplines.vams"
module private_synchronous_lp_state(demod_sample,baseband_ref,event_strobe,rst,enable,hold,voutp,voutn,settled,offset_residual);
input demod_sample,baseband_ref,event_strobe,rst,enable,hold; output voutp,voutn,settled,offset_residual;
electrical demod_sample,baseband_ref,event_strobe,rst,enable,hold,voutp,voutn,settled,offset_residual;
parameter real vdd=0.9,vss=0.0,vcm=0.45,vth=0.45,gain=3.0,lp_alpha=0.25,settle_tol=20m,tr=100p;
parameter integer settle_cycles=3;
real baseband_q,residual_q,outp_q,outn_q,settled_q; integer converged_q;
analog begin
 @(initial_step) begin baseband_q=0; residual_q=0; outp_q=vcm; outn_q=vcm; settled_q=vss; converged_q=0; end
 @(cross(V(event_strobe)-vth,+1) or cross(V(event_strobe)-vth,-1)) begin
  if((V(rst)>vth)||(V(enable)<=vth)) begin baseband_q=0; residual_q=0; outp_q=vcm; outn_q=vcm; settled_q=vss; converged_q=0; end
  else begin
   baseband_q=baseband_q+lp_alpha*(V(demod_sample)-baseband_q); residual_q=baseband_q-V(baseband_ref);
   if(abs(residual_q)<=settle_tol) converged_q=converged_q+1; else converged_q=0; settled_q=(converged_q>=settle_cycles)?vdd:vss;
   outp_q=vcm+0.5*baseband_q; outn_q=vcm-0.5*baseband_q;
   if(outp_q>vdd)outp_q=vdd; if(outp_q<vss)outp_q=vss; if(outn_q>vdd)outn_q=vdd; if(outn_q<vss)outn_q=vss;
  end
 end
 @(cross(V(rst)-vth,+1) or cross(V(enable)-vth,-1)) begin baseband_q=0; residual_q=0; outp_q=vcm; outn_q=vcm; settled_q=vss; converged_q=0; end
 V(voutp)<+transition(outp_q,0,tr,tr); V(voutn)<+transition(outn_q,0,tr,tr); V(settled)<+transition(settled_q,0,tr,tr); V(offset_residual)<+transition(residual_q,0,tr,tr);
end
endmodule
