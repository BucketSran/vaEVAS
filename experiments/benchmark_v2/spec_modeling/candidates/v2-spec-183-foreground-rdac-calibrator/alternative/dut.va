`include "disciplines.vams"
module foreground_rdac_calibrator(ck,d,vrefp,vrefn,dc0,dc1,dc2,dc3,dc4,dc5,dc6,cvinp,cvinn,en,enb);
input ck,d,vrefp,vrefn;output dc0,dc1,dc2,dc3,dc4,dc5,dc6,cvinp,cvinn,en,enb;
electrical ck,d,vrefp,vrefn,dc0,dc1,dc2,dc3,dc4,dc5,dc6,cvinp,cvinn,en,enb;
parameter real vdd=1.0;integer word,k,active;
analog begin
 @(initial_step)begin word=64;k=6;active=1;end
 @(cross(V(ck)-vdd/2,+1))begin if(active)begin
 if(V(d)>=vdd/2)word=word & ~(1<<k);
 k=k-1;if(k>=0)word=word | (1<<k);else active=0;
 end end
 V(cvinp)<+V(vrefp);V(cvinn)<+V(vrefn);
 V(dc0)<+transition((word&1)?vdd:0,0,20p,20p);V(dc1)<+transition((word&2)?vdd:0,0,20p,20p);V(dc2)<+transition((word&4)?vdd:0,0,20p,20p);V(dc3)<+transition((word&8)?vdd:0,0,20p,20p);V(dc4)<+transition((word&16)?vdd:0,0,20p,20p);V(dc5)<+transition((word&32)?vdd:0,0,20p,20p);V(dc6)<+transition((word&64)?vdd:0,0,20p,20p);
 V(en)<+transition(active?vdd:0,0,20p,20p);V(enb)<+transition(active?0:vdd,0,20p,20p);
end
endmodule
