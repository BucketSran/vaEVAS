`include "constants.vams"
`include "disciplines.vams"

module nonoverlap_clock_generator(clk_in, rst, enable, phi1, phi2, deadtime_metric, valid);
    input clk_in, rst, enable;
    output phi1, phi2, deadtime_metric, valid;
    electrical clk_in, rst, enable, phi1, phi2, deadtime_metric, valid;

    parameter real vdd = 0.9;
    parameter real vss = 0.0;
    parameter real vth = 0.45;
    parameter integer dead_ticks = 5 from [1:100];
    parameter real tick = 200p from (0:inf);
    parameter real tr = 100p from (0:inf);

    integer active_phase;
    integer pending_phase;
    integer wait_ticks;
    integer global_tick_index;
    integer valid_state;
    real phi1_v;
    real phi2_v;
    real metric_v;
    real valid_v;

    analog begin
        @(initial_step) begin
            global_tick_index = -1;
            active_phase = 0;
            pending_phase = 0;
            wait_ticks = 0;
            valid_state = 0;
        end

        @(cross(V(clk_in) - vth, +1)) begin
            if (V(rst) > vth || V(enable) <= vth) begin
                active_phase = 0;
                pending_phase = 0;
                wait_ticks = 0;
                valid_state = 0;
            end else begin
                active_phase = 0;
                pending_phase = 1;
                wait_ticks = global_tick_index + dead_ticks;
            end
        end

        @(cross(V(clk_in) - vth, -1)) begin
            if (V(rst) > vth || V(enable) <= vth) begin
                active_phase = 0;
                pending_phase = 0;
                wait_ticks = 0;
                valid_state = 0;
            end else begin
                active_phase = 0;
                pending_phase = 2;
                wait_ticks = global_tick_index + dead_ticks;
            end
        end

        @(cross(V(rst)-vth,+1) or cross(V(enable)-vth,-1)) begin
 active_phase=0;pending_phase=0;wait_ticks=0;valid_state=0;
 end

 @(timer(0, tick)) begin
            global_tick_index = global_tick_index + 1;
            if (V(rst) > vth || V(enable) <= vth) begin
                active_phase = 0;
                pending_phase = 0;
                wait_ticks = 0;
                valid_state = 0;
            end else if (pending_phase != 0) begin
                if (global_tick_index >= wait_ticks) begin
                    active_phase = pending_phase;
                    pending_phase = 0;
                    valid_state = 1;
                end
            end
        end

        phi1_v = (V(rst) <= vth && V(enable) > vth && active_phase == 1) ? vdd : vss;
        phi2_v = (V(rst) <= vth && V(enable) > vth && active_phase == 2) ? vdd : vss;
        metric_v = (V(rst) <= vth && V(enable) > vth && pending_phase != 0 && active_phase == 0) ? vdd : vss;
        valid_v = (V(rst) <= vth && V(enable) > vth && valid_state != 0) ? vdd : vss;

        V(phi1) <+ transition(phi1_v,0,tr,tr);
        V(phi2) <+ transition(phi2_v,0,tr,tr);
        V(deadtime_metric) <+ transition(metric_v,0,tr,tr);
        V(valid) <+ transition(valid_v,0,tr,tr);
    end
endmodule
