`include "constants.vams"
`include "disciplines.vams"

module ffe_tx_3tap(data, clk, rst, pre_1, pre_0, post_1, post_0, vout, main_dbg, pre_dbg, post_dbg);
    input data, clk, rst, pre_1, pre_0, post_1, post_0;
    output vout, main_dbg, pre_dbg, post_dbg;
    electrical data, clk, rst, pre_1, pre_0, post_1, post_0, vout, main_dbg, pre_dbg, post_dbg;

    parameter real vdd = 0.9;
    parameter real vss = 0.0;
    parameter real vcm = 0.45;
    parameter real vth = 0.45;
    parameter real main_amp = 0.18;
    parameter real tap_step = 0.04;
    parameter real tr = 120p from (0:inf);

    integer history[0:2]; integer head;
    integer sym0;
    integer sym1;
    integer sym2;
    integer pre_code;
    integer post_code;
    real main_value;
    real pre_value;
    real post_value;
    real out_value;

    analog begin
        @(initial_step) begin
            history[0]=0;history[1]=0;history[2]=0;head=2;
            sym0 = 0;
            sym1 = 0;
            sym2 = 0;
            main_value = vcm;
            pre_value = vcm;
            post_value = vcm;
            out_value = vcm;
        end

        @(cross(V(clk) - vth, +1)) begin
            if (V(rst) > vth) begin
                history[0]=0;history[1]=0;history[2]=0;head=2;
            sym0 = 0;
                sym1 = 0;
                sym2 = 0;
                main_value = vcm;
                pre_value = vcm;
                post_value = vcm;
                out_value = vcm;
            end else begin
                head=(head+1)%3;history[head]=(V(data)>vth)?1:-1;
                sym0=history[head];sym1=history[(head+2)%3];sym2=history[(head+1)%3];
                pre_code = 0;
                post_code = 0;
                if (V(pre_0) > vth) pre_code = pre_code + 1;
                if (V(pre_1) > vth) pre_code = pre_code + 2;
                if (V(post_0) > vth) post_code = post_code + 1;
                if (V(post_1) > vth) post_code = post_code + 2;
                main_value = vcm + main_amp * sym0;
                pre_value = vcm + tap_step * pre_code * sym1;
                post_value = vcm - tap_step * post_code * sym2;
                out_value = vcm + main_amp * sym0 + tap_step * pre_code * sym1 - tap_step * post_code * sym2;
                if (out_value > vdd)
                    out_value = vdd;
                if (out_value < vss)
                    out_value = vss;
            end
        end

        V(vout) <+ transition(out_value, 0, tr, tr);
        V(main_dbg) <+ transition(main_value, 0, tr, tr);
        V(pre_dbg) <+ transition(pre_value, 0, tr, tr);
        V(post_dbg) <+ transition(post_value, 0, tr, tr);
    end
endmodule
