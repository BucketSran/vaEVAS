`include "disciplines.vams"
module hysteretic_window_comparator(vin,rst,enable,low_trip,high_trip,inside_flag,state_metric,toggled);
input vin,rst,enable,low_trip,high_trip;output inside_flag,state_metric,toggled;
electrical vin,rst,enable,low_trip,high_trip,inside_flag,state_metric,toggled;
parameter real vdd=0.9,vss=0,vcm=0.45,vth=0.45,tr=200p,hyst=0.01,pulse=1n;
real state,oldstate;real pulse_end,pulse_level;
analog begin
 @(initial_step) begin state=vss;oldstate=vss;pulse_end=1e99;pulse_level=vss;end
 @(cross(V(vin)-V(low_trip)-hyst,+1) or cross(V(vin)-V(high_trip)+hyst,-1) or cross(V(vin)-V(low_trip)+hyst,-1) or cross(V(vin)-V(high_trip)-hyst,+1) or cross(V(rst)-vth,+1) or cross(V(enable)-vth,-1) or cross(V(enable)-vth,+1) or cross(V(rst)-vth,-1)) begin
  oldstate=state;
  if(V(rst)>vth || V(enable)<=vth) begin state=vss;pulse_level=vss;pulse_end=1e99;end
  else begin
   if(state==vss && V(vin)>=V(low_trip)+hyst && V(vin)<=V(high_trip)-hyst)state=vdd;
   else if(state==vdd && (V(vin)<=V(low_trip)-hyst || V(vin)>=V(high_trip)+hyst))state=vss;
   if(state!=oldstate)begin pulse_level=vdd;pulse_end=$abstime+pulse;end
  end
 end
 @(timer(pulse_end))begin pulse_level=vss;end
 V(inside_flag)<+transition(state,0,tr,tr);V(state_metric)<+transition(state,0,tr,tr);V(toggled)<+transition(pulse_level,0,tr,tr);
end
endmodule
