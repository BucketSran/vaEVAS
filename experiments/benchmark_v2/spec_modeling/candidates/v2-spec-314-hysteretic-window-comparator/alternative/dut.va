`include "disciplines.vams"
module hysteretic_window_comparator(vin,rst,enable,low_trip,high_trip,inside_flag,state_metric,toggled);
input vin,rst,enable,low_trip,high_trip;output inside_flag,state_metric,toggled;
electrical vin,rst,enable,low_trip,high_trip,inside_flag,state_metric,toggled;
parameter real vdd=0.9,vss=0,vcm=0.45,vth=0.45,tr=200p,hyst=0.01,pulse=1n;
integer outside,oldstate;real pulse_end,pulse_level;
analog begin
 @(initial_step) begin outside=1;oldstate=0;pulse_end=1e99;pulse_level=vss;end
 @(cross(V(vin)-V(low_trip)-hyst,+1) or cross(V(vin)-V(high_trip)+hyst,-1) or cross(V(vin)-V(low_trip)+hyst,-1) or cross(V(vin)-V(high_trip)-hyst,+1) or cross(V(rst)-vth,+1) or cross(V(enable)-vth,-1) or cross(V(enable)-vth,+1) or cross(V(rst)-vth,-1)) begin
  oldstate=outside;
  if(V(rst)>vth || V(enable)<=vth) begin outside=1;pulse_level=vss;pulse_end=1e99;end
  else begin
   if(outside==1 && V(vin)>=V(low_trip)+hyst && V(vin)<=V(high_trip)-hyst)outside=0;
   else if(outside==0 && (V(vin)<=V(low_trip)-hyst || V(vin)>=V(high_trip)+hyst))outside=1;
   if(outside!=oldstate)begin pulse_level=vdd;pulse_end=$abstime+pulse;end
  end
 end
 @(timer(pulse_end))begin if($abstime>=pulse_end)pulse_level=vss;end
 V(inside_flag)<+transition(outside?vss:vdd,0,tr,tr);V(state_metric)<+transition(outside?vss:vdd,0,tr,tr);V(toggled)<+transition(pulse_level,0,tr,tr);
end
endmodule
