`include "constants.vams"
`include "disciplines.vams"

module acquisition_limited_sample_hold(sample, rst, vin, vout, metric);
    input sample, rst, vin;
    output vout, metric;
    electrical sample, rst, vin, vout, metric;

    parameter real vth = 0.45;
    parameter real vinit = 0.45;
    parameter real alpha = 0.42 from (0:1];
    parameter real tick = 1n from (0:inf);
    parameter real tr = 200p from (0:inf);

    real deficit;
    real tracking;

    analog begin
        @(initial_step) begin
            deficit = 0;
            tracking = 0.0;
        end

        @(cross(V(sample) - vth, +1)) begin
            if (V(rst) > vth) begin
                deficit = 0;
                tracking = 0.0;
            end else begin
                tracking = 1.0;
            end
        end

        @(cross(V(sample) - vth, -1)) begin
            tracking = 0.0;
        end

        @(timer(0, tick)) begin
            if (V(rst) > vth) begin
                deficit = 0;
                tracking = 0.0;
            end else if (tracking > 0.5) begin
                deficit = (1-alpha)*deficit + alpha*(vinit-V(vin));
            end
        end

        V(vout) <+ transition(vinit-deficit, 0, tr, tr);
        V(metric) <+ transition((tracking > 0.5) ? 0.9 : 0.0, 0, tr, tr);
    end
endmodule
