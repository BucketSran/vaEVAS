`include "disciplines.vams"
module sarfend_logic_4b(clks,dcomp,dcompb,test,dtest0,dtest1,dtest2,dtest3,clkc,dp1,dp2,dp3,dp4,dm1,dm2,dm3,dm4,dout0,dout1,dout2,dout3);
input clks,dcomp,dcompb,test,dtest0,dtest1,dtest2,dtest3;output clkc,dp1,dp2,dp3,dp4,dm1,dm2,dm3,dm4,dout0,dout1,dout2,dout3;
electrical clks,dcomp,dcompb,test,dtest0,dtest1,dtest2,dtest3,clkc,dp1,dp2,dp3,dp4,dm1,dm2,dm3,dm4,dout0,dout1,dout2,dout3;
integer pword,mword,published,override,k,request,decision,mask;
analog begin
 @(initial_step)begin pword=7;mword=7;published=0;override=0;k=3;request=0;end
 @(cross(V(clks)-0.45,+1))begin
 published=pword;pword=7;mword=7;k=3;request=0;
 override=(V(dtest0)>0.45)+2*(V(dtest1)>0.45)+4*(V(dtest2)>0.45)+8*(V(dtest3)>0.45);
 end
 @(cross(V(clks)-0.45,-1))request=1;
 @(cross(V(dcomp)+V(dcompb)-0.45,-1))if(V(clks)<0.45 && k>=0)request=1;
 @(cross(V(dcomp)+V(dcompb)-0.45,+1))begin
 if(V(clks)<0.45 && k>=0)begin
 mask=1<<k;decision=(V(test)>0.45)?((override&mask)!=0):(V(dcomp)>V(dcompb));
 pword=(pword & ~mask) | (decision?mask:0);mword=(mword & ~mask) | (decision?0:mask);
 k=k-1;request=0;
 end end
 V(dp1)<+transition((pword&1)?1:0,20p,10p,10p);V(dp2)<+transition((pword&2)?1:0,20p,10p,10p);V(dp3)<+transition((pword&4)?1:0,20p,10p,10p);V(dp4)<+transition((pword&8)?1:0,20p,10p,10p);
 V(dm1)<+transition((mword&1)?1:0,20p,10p,10p);V(dm2)<+transition((mword&2)?1:0,20p,10p,10p);V(dm3)<+transition((mword&4)?1:0,20p,10p,10p);V(dm4)<+transition((mword&8)?1:0,20p,10p,10p);
 V(dout0)<+transition((published&1)?1:0,0,10p,10p);V(dout1)<+transition((published&2)?1:0,0,10p,10p);V(dout2)<+transition((published&4)?1:0,0,10p,10p);V(dout3)<+transition((published&8)?1:0,0,10p,10p);
 V(clkc)<+transition(request,30p,10p,10p);
end
endmodule
