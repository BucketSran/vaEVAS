`include "constants.vams"
`include "disciplines.vams"

module uvlo_brownout_detector(clk, rst, vin, out, metric);
input clk, rst, vin;
output out, metric;
electrical clk, rst, vin, out, metric;
parameter real tr = 100p;
parameter real vth = 0.45;
integer state; real pgood, metricv;
analog begin
    @(initial_step) begin
        state = 0; pgood = 0.0;
        metricv = 0.9;
    end
    @(cross(V(clk)-vth,1)) begin
      if(V(rst)>vth) state=0;
      else if(V(vin)>0.65) state=1;
      else if(V(vin)<0.55) state=0;
      pgood=0.9*state; metricv=0.9-0.8*state;
    end
    V(out) <+ transition(pgood, 0, tr, tr);
    V(metric) <+ transition(metricv, 0, tr, tr);
end
endmodule
