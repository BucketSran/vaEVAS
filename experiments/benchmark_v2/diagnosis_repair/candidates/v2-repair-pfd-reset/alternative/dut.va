`include "disciplines.vams"
module pfd_active_low_reset(ref, fb, rstb, up, down);
input ref, fb, rstb;
output up, down;
electrical ref, fb, rstb, up, down;
parameter real vth = 0.45;
parameter real vh = 0.9;
parameter real reset_delay = 80p from [0:inf);
parameter real tr = 10p from [0:inf);
real up_state, down_state;
real trst;
analog begin
    @(initial_step) begin
        up_state = 0;
        down_state = 0;
        trst = -1.0;
    end
    @(cross(V(rstb) - vth, -1)) begin
        up_state = 0;
        down_state = 0;
        trst = -1.0;
    end
    @(cross(V(ref) - vth, +1)) begin
        if (V(rstb) > vth) begin
            up_state = 1;
            if (down_state == 1) trst = max($abstime,0) + reset_delay;
        end
    end
    @(cross(V(fb) - vth, +1)) begin
        if (V(rstb) > vth) begin
            down_state = 1;
            if (up_state == 1) trst = max($abstime,0) + reset_delay;
        end
    end
    @(timer(0,1p)) begin
        if (trst>=0 && $abstime>=trst) begin
        up_state = 0;
        down_state = 0;
        trst = -1.0;
    end
    end
    if (V(rstb) <= vth) begin
        up_state = 0;
        down_state = 0;
        trst = -1.0;
    end
    V(up) <+ transition(up_state ? vh : 0.0, 0, tr);
    V(down) <+ transition(down_state ? vh : 0.0, 0, tr);
end
endmodule
