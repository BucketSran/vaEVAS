// Self-contained demo model for static_sum.json: three additive contributions.
`include "constants.vams"
`include "disciplines.vams"
module dvs_sum(u, v, vout, vref);
    input u, v;
    output vout;
    inout vref;
    electrical u, v, vout, vref;
    parameter real g1 = 1.5;
    parameter real g2 = -0.5;
    parameter real bias = 0.125;
    analog begin
        V(vout, vref) <+ g1*V(u, vref);
        V(vout, vref) <+ g2*V(v, vref);
        V(vout, vref) <+ bias;
    end
endmodule
