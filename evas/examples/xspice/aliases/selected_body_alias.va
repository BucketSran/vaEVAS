`include "disciplines.vams"
module alias_box(clk,vin,vdd,vss,y);
input clk,vin,vdd,vss; output y;
electrical clk,vin,vdd,vss,y;
real vh,vl,vth,a,q;
analog begin
 @(initial_step)q=0;
 vh=V(vdd); vl=V(vss); vth=(vh+vl)/2;
 a=(V(vin,vss)>0.25)?V(vin,vss):0;
 @(cross(V(clk)-vth,+1))q=a;
 V(y)<+transition(q,0,50p,50p);
end
endmodule
