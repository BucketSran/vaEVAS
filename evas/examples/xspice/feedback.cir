EVAS-generated sample hold with an RC feedback path
.include model.inc
vclock clk 0 pulse(0 1.8 1u 10n 10n 1u 3u)
vbias bias out 0.2
rfb bias din 1k
cfb din 0 1n
a_sh din clk out held count ticks order stamp sample_hold_cm
.save v(clk) v(din) v(out) v(held) v(count) v(ticks) v(order) v(stamp)
.options method=gear maxord=2 reltol=1e-9 vntol=1e-12 abstol=1e-15
.tran 1n 8.4u 0 1n
.control
set filetype=ascii
set numdgt=17
run
write wave.raw all
quit
.endc
.end
