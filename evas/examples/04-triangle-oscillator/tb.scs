simulator lang=spectre
ahdl_include "dut.va"
Vctl (ctl 0) vsource type=pwl wave=[0 1 3 1]
Xdut (ctl z count 0) triangle lower=-0.5 upper=0.5 initial_voltage=0.0 direction=1 ttol=1e-10 vtol=1e-10
simulatorOptions options reltol=1e-12 vabstol=1e-14 iabstol=1e-18
tran tran stop=3.0 step=0.005 maxstep=0.005 method=traponly
save ctl z count
