module m(u,y,r); input u; output y; inout r; electrical u,y,r; integer n,q,h,m;electrical z; analog begin @(initial_step) begin n=0;q=0;h=0;m=0;end
@(timer(0.1,0.2,1e-15)) begin n=n+1;q=n-1;end
@(timer(0.30000000000000004,0,1e-15)) m=m+1;
V(z,r)<+idt(q,0);
@(cross(V(z,r)-1e-18,1,1e-06,1e-06)) h=h+1;
V(y,r)<+h; end endmodule
