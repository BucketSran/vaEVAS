`include "disciplines.vams"
module source_closure(u,y,z,w,count,flag,mark,r);
inout u,y,z,w,count,flag,mark,r;
electrical u,y,z,w,count,flag,mark,r;
parameter real polarity=1;
integer n,q,h,m;
analog begin
@(initial_step) begin n=0;q=0;h=0;m=0;end
@(timer(0.1,0.2,1e-9)) begin n=n+1;q=n-1;end
@(timer(0.30000000000000004,0,1e-9)) m=m+1;
V(z,r)<+idt(polarity*(q+h)*V(u,r),0);
V(w,r)<+idt(V(u,r)+q,0);
@(cross(polarity*V(z,r)-0.002,1,1e-9,1e-9)) h=h+1;
V(y,r)<+V(z,r)+V(w,r);
V(count,r)<+n;V(flag,r)<+h;V(mark,r)<+m;
end
endmodule
