`include "disciplines.vams"
module runtime_observer(u);
input u; electrical u;
integer n,i,acc,q,rem,a[0:3];
analog begin
 @(timer(0.25,0,1e-12)) n=4;
 @(timer(0.5,0,1e-12)) begin
q=(n+1)/2;
rem=(n+1)%2;
for(i=0;i<(n+1)/2;i=i+1) begin
 a[i+(n+1)%2]=(n+1)/2+i;
 acc=acc+a[i+(n+1)%2];
end
 $display("IR23_RESULT te=%.17g n=%.17g i=%.17g q=%.17g rem=%.17g acc=%.17g a0=%.17g a1=%.17g a2=%.17g a3=%.17g",$abstime,n,i,q,rem,acc,a[0],a[1],a[2],a[3]);
 end
end
endmodule
