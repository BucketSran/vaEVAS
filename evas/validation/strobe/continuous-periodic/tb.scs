simulator lang=spectre
ahdl_include "dut.va"
Vu (u 0) vsource type=pwl wave=[0 0 1 1]
Xdut (u y 0) m
simulatorOptions options reltol=1e-7 vabstol=1e-9 iabstol=1e-12 precision="%24.17g"
tran tran stop=1 maxstep=0.5 errpreset=conservative strobeperiod=0.25 strobedelay=0.125 strobeoutput=all
save u y
