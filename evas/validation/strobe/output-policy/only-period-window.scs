simulator lang=spectre
ahdl_include "dut.va"
Vin (u 0) vsource type=pwl wave=[0 0 .25 0 .375 1 .4375 0 1 0]
X (y u) gain
opts options reltol=1e-10 vabstol=1e-12 iabstol=1e-16
tran tran stop=1 maxstep=.25 strobeperiod=.25 strobedelay=.125 skipstart=.2 skipstop=.8 strobeoutput=strobeonly
save u y
