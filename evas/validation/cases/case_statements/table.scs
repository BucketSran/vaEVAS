simulator lang=spectre
global 0
ahdl_include "dut.va"
v0 (u0 0) vsource type=dc dc=0
v1 (u1 0) vsource type=dc dc=1
v2 (u2 0) vsource type=dc dc=2
v3 (u3 0) vsource type=dc dc=-1
v4 (u4 0) vsource type=dc dc=0.5
x0 (u0 y0 f0) case_probe
x1 (u1 y1 f1) case_probe
x2 (u2 y2 f2) case_probe
x3 (u3 y3 f3) case_probe
x4 (u4 y4 f4) case_probe
opts options reltol=1e-6 vabstol=1e-9
tr tran stop=1 maxstep=0.125
save y0 f0 y1 f1 y2 f2 y3 f3 y4 f4
