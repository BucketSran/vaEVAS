module variable_array(u,y,r);
input u; output y; inout r;
electrical u,y,r;
parameter real N=3;
real a[0:N-1],sum;
genvar i;
analog begin
  sum=0;
  for(i=0;i<N;i=i+1) begin
    a[i]=(i+1)*V(u,r);
    sum=sum+a[i];
  end
  V(y,r)<+sum-2*V(y,r);
end
endmodule
