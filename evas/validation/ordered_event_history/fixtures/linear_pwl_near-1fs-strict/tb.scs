simulator lang=spectre
ahdl_include "compile.va"
Vu (u 0) vsource type=pwl wave=[0 0 6.0000000000000002e-06 1 6.9999999999999999e-06 1]
Xdut (u y 0) m
simulatorOptions options reltol=1e-10 vabstol=1e-12 iabstol=1e-16 precision="%24.17g" saveahdlvars=allwithnodes
tran tran stop=7e-6 step=1.1000000000000001e-07 maxstep=1.1000000000000001e-07 method=traponly strobetimes=[0 1.1000000000000001e-07 2.2000000000000001e-07 3.3000000000000002e-07 4.4000000000000002e-07 5.5000000000000003e-07 6.6000000000000003e-07 7.7000000000000004e-07 8.8000000000000004e-07 9.9000000000000005e-07 1.1000000000000001e-06 1.2100000000000001e-06 1.3200000000000001e-06 1.4300000000000001e-06 1.5400000000000001e-06 1.6500000000000001e-06 1.7600000000000001e-06 1.8700000000000001e-06 1.9800000000000001e-06 1.9979999999999998e-06 1.9980499999999999e-06 1.9981e-06 1.9981500000000001e-06 1.9981999999999998e-06 1.9982499999999999e-06 1.9983e-06 1.9983500000000001e-06 1.9983999999999998e-06 1.9984499999999999e-06 1.9985e-06 1.9985500000000001e-06 1.9985999999999998e-06 1.9986499999999999e-06 1.9987e-06 1.9987499999999997e-06 1.9987999999999998e-06 1.9988499999999999e-06 1.9989e-06 1.9989499999999997e-06 1.9989999999999998e-06 1.9990499999999999e-06 1.9991000000000001e-06 1.9991499999999997e-06 1.9991999999999998e-06 1.99925e-06 1.9993000000000001e-06 1.9993499999999998e-06 1.9993999999999999e-06 1.99945e-06 1.9995000000000001e-06 1.9995499999999998e-06 1.9995999999999999e-06 1.99965e-06 1.9997000000000001e-06 1.9997499999999998e-06 1.9997999999999999e-06 1.99985e-06 1.9999000000000001e-06 1.9999499999999998e-06 1.9999999999999999e-06 2.00005e-06 2.0000999999999997e-06 2.0001499999999998e-06 2.0001999999999999e-06 2.00025e-06 2.0002999999999997e-06 2.0003499999999998e-06 2.0003999999999999e-06 2.00045e-06 2.0004999999999997e-06 2.0005499999999998e-06 2.0006e-06 2.0006500000000001e-06 2.0006999999999998e-06 2.0007499999999999e-06 2.0008e-06 2.0008500000000001e-06 2.0008999999999998e-06 2.0009499999999999e-06 2.001e-06 2.0010500000000001e-06 2.0010999999999998e-06 2.0011499999999999e-06 2.0012e-06 2.0012500000000001e-06 2.0012999999999998e-06 2.0013499999999999e-06 2.0014e-06 2.0014499999999997e-06 2.0014999999999998e-06 2.0015499999999999e-06 2.0016e-06 2.0016499999999997e-06 2.0016999999999998e-06 2.0017499999999999e-06 2.0018e-06 2.0018499999999997e-06 2.0018999999999998e-06 2.00195e-06 2.0020000000000001e-06 2.0899999999999999e-06 2.2000000000000001e-06 2.3099999999999999e-06 2.4200000000000001e-06 2.5299999999999999e-06 2.6400000000000001e-06 2.7499999999999999e-06 2.8600000000000001e-06 2.9699999999999999e-06 2.9979999999999999e-06 2.99805e-06 2.9981000000000001e-06 2.9981500000000003e-06 2.9981999999999999e-06 2.9982500000000001e-06 2.9983000000000002e-06 2.9983500000000003e-06 2.9984e-06 2.9984500000000001e-06 2.9985000000000002e-06 2.9985500000000003e-06 2.9986e-06 2.9986500000000001e-06 2.9987000000000002e-06 2.9987499999999999e-06 2.9988e-06 2.9988500000000001e-06 2.9989000000000002e-06 2.9989499999999999e-06 2.999e-06 2.9990500000000001e-06 2.9991000000000002e-06 2.9991499999999999e-06 2.9992e-06 2.9992500000000001e-06 2.9993000000000002e-06 2.9993499999999999e-06 2.9994e-06 2.9994500000000001e-06 2.9995000000000003e-06 2.9995499999999999e-06 2.9996e-06 2.9996500000000002e-06 2.9997000000000003e-06 2.99975e-06 2.9998000000000001e-06 2.9998500000000002e-06 2.9999000000000003e-06 2.99995e-06 3.0000000000000001e-06 3.0000500000000002e-06 3.0000999999999999e-06 3.00015e-06 3.0002000000000001e-06 3.0002500000000002e-06 3.0002999999999999e-06 3.00035e-06 3.0004000000000001e-06 3.0004500000000002e-06 3.0004999999999999e-06 3.00055e-06 3.0006000000000001e-06 3.0006500000000002e-06 3.0006999999999999e-06 3.00075e-06 3.0008000000000001e-06 3.0008500000000002e-06 3.0008999999999999e-06 3.00095e-06 3.0010000000000002e-06 3.0010500000000003e-06 3.0010999999999999e-06 3.0011500000000001e-06 3.0012000000000002e-06 3.0012500000000003e-06 3.0013e-06 3.0013500000000001e-06 3.0014000000000002e-06 3.0014499999999999e-06 3.0015e-06 3.0015500000000001e-06 3.0016000000000002e-06 3.0016499999999999e-06 3.0017e-06 3.0017500000000001e-06 3.0018000000000002e-06 3.0018499999999999e-06 3.0019e-06 3.0019500000000001e-06 3.0020000000000002e-06 3.0800000000000002e-06 3.19e-06 3.3000000000000002e-06 3.41e-06 3.5200000000000002e-06 3.63e-06 3.7400000000000002e-06 3.8500000000000004e-06 3.9600000000000002e-06 3.9979999999999997e-06 3.9980499999999998e-06 3.9980999999999999e-06 3.99815e-06 3.9982000000000001e-06 3.9982500000000002e-06 3.9982999999999995e-06 3.9983499999999996e-06 3.9983999999999997e-06 3.9984499999999998e-06 3.9984999999999999e-06 3.99855e-06 3.9986000000000001e-06 3.9986499999999994e-06 3.9986999999999995e-06 3.9987499999999996e-06 3.9987999999999997e-06 3.9988499999999998e-06 3.9988999999999999e-06 3.9989500000000001e-06 3.9990000000000002e-06 3.9990499999999994e-06 3.9990999999999995e-06 3.9991499999999996e-06 3.9991999999999998e-06 3.9992499999999999e-06 3.9993e-06 3.9993500000000001e-06 3.9994000000000002e-06 3.9994499999999995e-06 3.9994999999999996e-06 3.9995499999999997e-06 3.9995999999999998e-06 3.9996499999999999e-06 3.9997e-06 3.9997500000000001e-06 3.9998000000000002e-06 3.9998499999999995e-06 3.9998999999999996e-06 3.9999499999999997e-06 3.9999999999999998e-06 4.0000499999999999e-06 4.0001e-06 4.0001500000000001e-06 4.0001999999999994e-06 4.0002499999999995e-06 4.0002999999999996e-06 4.0003499999999997e-06 4.0003999999999998e-06 4.00045e-06 4.0005000000000001e-06 4.0005500000000002e-06 4.0005999999999994e-06 4.0006499999999996e-06 4.0006999999999997e-06 4.0007499999999998e-06 4.0007999999999999e-06 4.00085e-06 4.0009000000000001e-06 4.0009500000000002e-06 4.0009999999999995e-06 4.0010499999999996e-06 4.0010999999999997e-06 4.0011499999999998e-06 4.0011999999999999e-06 4.00125e-06 4.0013000000000001e-06 4.0013500000000002e-06 4.0013999999999995e-06 4.0014499999999996e-06 4.0014999999999997e-06 4.0015499999999998e-06 4.0015999999999999e-06 4.00165e-06 4.0017000000000002e-06 4.0017499999999994e-06 4.0017999999999995e-06 4.0018499999999996e-06 4.0018999999999997e-06 4.0019499999999999e-06 4.002e-06 4.07e-06 4.1799999999999998e-06 4.2899999999999996e-06 4.4000000000000002e-06 4.51e-06 4.6199999999999998e-06 4.7299999999999996e-06 4.8400000000000002e-06 4.95e-06 5.0599999999999998e-06 5.1699999999999996e-06 5.2800000000000003e-06 5.3900000000000001e-06 5.4999999999999999e-06 5.6099999999999997e-06 5.7200000000000003e-06 5.8300000000000001e-06 5.9399999999999999e-06 5.998e-06 5.9980500000000001e-06 5.9980999999999994e-06 5.9981000000000002e-06 5.9981499999999995e-06 5.9981500000000003e-06 5.9981999999999996e-06 5.9982000000000004e-06 5.9982499999999997e-06 5.9982500000000005e-06 5.9982999999999998e-06 5.9983499999999999e-06 5.9984e-06 5.9984500000000001e-06 5.9984999999999994e-06 5.9985000000000003e-06 5.9985499999999995e-06 5.9985500000000004e-06 5.9985999999999996e-06 5.9986000000000005e-06 5.9986499999999997e-06 5.9986999999999998e-06 5.99875e-06 5.9988000000000001e-06 5.9988499999999993e-06 5.9988500000000002e-06 5.9988999999999994e-06 5.9989000000000003e-06 5.9989499999999995e-06 5.9989500000000004e-06 5.9989999999999997e-06 5.9990000000000005e-06 5.9990499999999998e-06 5.9990999999999999e-06 5.99915e-06 5.9992000000000001e-06 5.9992499999999994e-06 5.9992500000000002e-06 5.9992999999999995e-06 5.9993000000000003e-06 5.9993499999999996e-06 5.9993500000000004e-06 5.9993999999999997e-06 5.9994000000000005e-06 5.9994499999999998e-06 5.9994999999999999e-06 5.99955e-06 5.9996000000000001e-06 5.9996499999999994e-06 5.9996500000000002e-06 5.9996999999999995e-06 5.9997000000000003e-06 5.9997499999999996e-06 5.9997500000000005e-06 5.9997999999999997e-06 5.9998000000000006e-06 5.9998499999999998e-06 5.9998999999999999e-06 5.99995e-06 6.0000000000000002e-06 6.0000499999999994e-06 6.0000500000000003e-06 6.0000999999999995e-06 6.0001000000000004e-06 6.0001499999999996e-06 6.0001500000000005e-06 6.0001999999999997e-06 6.0002499999999999e-06 6.0003e-06 6.0003500000000001e-06 6.0003999999999993e-06 6.0004000000000002e-06 6.0004499999999994e-06 6.0004500000000003e-06 6.0004999999999996e-06 6.0005000000000004e-06 6.0005499999999997e-06 6.0005500000000005e-06 6.0005999999999998e-06 6.0006499999999999e-06 6.0007e-06 6.0007500000000001e-06 6.0007999999999994e-06 6.0008000000000002e-06 6.0008499999999995e-06 6.0008500000000003e-06 6.0008999999999996e-06 6.0009000000000004e-06 6.0009499999999997e-06 6.0009500000000005e-06 6.0009999999999998e-06 6.0010499999999999e-06 6.0011e-06 6.0011500000000001e-06 6.0011999999999994e-06 6.0012000000000002e-06 6.0012499999999995e-06 6.0012500000000004e-06 6.0012999999999996e-06 6.0013000000000005e-06 6.0013499999999997e-06 6.0013500000000006e-06 6.0013999999999998e-06 6.0014499999999999e-06 6.0015000000000001e-06 6.0015499999999993e-06 6.0015500000000002e-06 6.0015999999999994e-06 6.0016000000000003e-06 6.0016499999999995e-06 6.0016500000000004e-06 6.0016999999999996e-06 6.0017000000000005e-06 6.0017499999999998e-06 6.0017999999999999e-06 6.00185e-06 6.0019000000000001e-06 6.0019499999999993e-06 6.0019500000000002e-06 6.0019999999999995e-06 6.0020000000000003e-06 6.0499999999999997e-06 6.1600000000000003e-06 6.2700000000000001e-06 6.3799999999999999e-06 6.4899999999999997e-06 6.6000000000000003e-06 6.7100000000000001e-06 6.8199999999999999e-06 6.9299999999999997e-06 6.9999999999999999e-06] strobeoutput=all
save u y Xdut.z Xdut:n Xdut:m Xdut:h Xdut:s
