`include "disciplines.vams"
module measure(x);input x;electrical x;real a,b;integer n;
analog begin @(initial_step)begin a=0;b=0;n=0;end
@(timer(0.5,0,1e-12))begin if(n>0) begin a=1.0/a;b=sqrt(-V(x));end else $display("empty %d",n); end
end endmodule
