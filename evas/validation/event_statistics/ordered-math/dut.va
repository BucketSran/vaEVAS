`include "disciplines.vams"
module measure(x);input x;electrical x;real a,b;integer n;
analog begin @(initial_step)begin a=0;b=0;n=0;end
@(timer(0.5,0,1e-12))begin a=V(x)+1;a=a*a;b=sqrt(a);a=max(-1.0,min(a,3.0));$display("math %g %g",a,b); end
end endmodule
