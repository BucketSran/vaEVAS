`include "gain.vams"
module language(u,y,r);
input u; output y; inout r; electrical u,y,r,a,b;
sum_child #(.offset(.25)) left(u,a,r);
sum_child #(.offset(.75)) right(u,b,r);
analog begin V(y,r)<+.25*V(y,r); V(y,r)<+V(a,r)+V(b,r); end
endmodule
module sum_child(u,y,r);
input u; output y; inout r; electrical u,y,r;
parameter real N=3;
parameter real offset=0;
real a[0:N-1],sum;
genvar i;
analog function real gain;
input x; real x;
begin gain=(.5+offset)*x; end
endfunction
analog begin
sum=0;
for(i=0;i<N;i=i+1) begin a[i]=`GAIN((i+1)*V(u,r)); sum=sum+a[i]; end
V(y,r)<+sum;
end
endmodule
