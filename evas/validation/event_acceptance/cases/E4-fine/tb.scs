simulator lang=spectre
ahdl_include "dut.va"
Vu (u 0) vsource type=pwl wave=[0 0 2 2]
Xdut (u count z history edit sample 0) m
simulatorOptions options precision="%24.17g" reltol=1e-8 vabstol=1e-10 iabstol=1e-14
tran tran stop=2 step=0.002 maxstep=0.002 method=traponly strobetimes=[0 0.002 0.0040000000000000001 0.0060000000000000001 0.0080000000000000002 0.01 0.012 0.014 0.016 0.017999999999999999 0.02 0.021999999999999999 0.024 0.025999999999999999 0.028000000000000001 0.029999999999999999 0.032000000000000001 0.034000000000000002 0.035999999999999997 0.037999999999999999 0.040000000000000001 0.042000000000000003 0.043999999999999997 0.045999999999999999 0.048000000000000001 0.050000000000000003 0.051999999999999998 0.053999999999999999 0.056000000000000001 0.058000000000000003 0.059999999999999998 0.062 0.064000000000000001 0.066000000000000003 0.068000000000000005 0.070000000000000007 0.071999999999999995 0.073999999999999996 0.075999999999999998 0.078 0.080000000000000002 0.082000000000000003 0.084000000000000005 0.085999999999999993 0.087999999999999995 0.089999999999999997 0.091999999999999998 0.094 0.096000000000000002 0.098000000000000004 0.10000000000000001 0.10199999999999999 0.104 0.106 0.108 0.11 0.112 0.114 0.11600000000000001 0.11799999999999999 0.12 0.122 0.124 0.126 0.128 0.13 0.13200000000000001 0.13400000000000001 0.13600000000000001 0.13800000000000001 0.14000000000000001 0.14199999999999999 0.14399999999999999 0.14599999999999999 0.14799999999999999 0.14999999999999999 0.152 0.154 0.156 0.158 0.16 0.16200000000000001 0.16400000000000001 0.16600000000000001 0.16800000000000001 0.17000000000000001 0.17199999999999999 0.17399999999999999 0.17599999999999999 0.17799999999999999 0.17999999999999999 0.182 0.184 0.186 0.188 0.19 0.192 0.19400000000000001 0.19600000000000001 0.19800000000000001 0.20000000000000001 0.20200000000000001 0.20399999999999999 0.20599999999999999 0.20799999999999999 0.20999999999999999 0.21199999999999999 0.214 0.216 0.218 0.22 0.222 0.224 0.22600000000000001 0.22800000000000001 0.23000000000000001 0.23200000000000001 0.23400000000000001 0.23599999999999999 0.23799999999999999 0.23999999999999999 0.24199999999999999 0.24399999999999999 0.246 0.248 0.249999 0.24999901999999999 0.24999904000000001 0.24999906 0.24999908000000001 0.2499991 0.24999911999999999 0.24999914000000001 0.24999916 0.24999917999999999 0.2499992 0.24999921999999999 0.24999924000000001 0.24999926 0.24999927999999999 0.24999930000000001 0.24999932 0.24999933999999999 0.24999936 0.24999937999999999 0.24999940000000001 0.24999942 0.24999943999999999 0.24999946000000001 0.24999948 0.24999950000000001 0.24999952 0.24999953999999999 0.24999956000000001 0.24999958 0.24999959999999999 0.24999962000000001 0.24999964 0.24999966000000001 0.24999968 0.24999969999999999 0.24999972000000001 0.24999974 0.24999975999999999 0.24999978 0.24999979999999999 0.24999982000000001 0.24999984 0.24999985999999999 0.24999988000000001 0.2499999 0.24999991999999999 0.24999994 0.24999995999999999 0.24999998000000001 0.25 0.25000001999999999 0.25000003999999998 0.25000006000000002 0.25000008000000001 0.2500001 0.25000011999999999 0.25000013999999998 0.25000016000000003 0.25000018000000002 0.25000020000000001 0.25000022 0.25000023999999998 0.25000025999999997 0.25000028000000002 0.25000030000000001 0.25000032 0.25000033999999999 0.25000035999999998 0.25000038000000002 0.25000040000000001 0.25000042 0.25000043999999999 0.25000045999999998 0.25000048000000002 0.25000050000000001 0.25000052 0.25000053999999999 0.25000055999999998 0.25000057999999997 0.25000060000000002 0.25000062000000001 0.25000064 0.25000065999999999 0.25000067999999998 0.25000070000000002 0.25000072000000001 0.25000074 0.25000075999999999 0.25000077999999998 0.25000080000000002 0.25000082000000001 0.25000084 0.25000085999999999 0.25000087999999998 0.25000090000000003 0.25000092000000002 0.25000094 0.25000095999999999 0.25000097999999998 0.25000099999999997 0.252 0.254 0.25600000000000001 0.25800000000000001 0.26000000000000001 0.26200000000000001 0.26400000000000001 0.26600000000000001 0.26800000000000002 0.27000000000000002 0.27200000000000002 0.27400000000000002 0.27600000000000002 0.27800000000000002 0.28000000000000003 0.28199999999999997 0.28399999999999997 0.28599999999999998 0.28799999999999998 0.28999999999999998 0.29199999999999998 0.29399999999999998 0.29599999999999999 0.29799999999999999 0.29999999999999999 0.30199999999999999 0.30399999999999999 0.30599999999999999 0.308 0.31 0.312 0.314 0.316 0.318 0.32000000000000001 0.32200000000000001 0.32400000000000001 0.32600000000000001 0.32800000000000001 0.33000000000000002 0.33200000000000002 0.33400000000000002 0.33600000000000002 0.33800000000000002 0.34000000000000002 0.34200000000000003 0.34399999999999997 0.34599999999999997 0.34799999999999998 0.34999999999999998 0.35199999999999998 0.35399999999999998 0.35599999999999998 0.35799999999999998 0.35999999999999999 0.36199999999999999 0.36399999999999999 0.36599999999999999 0.36799999999999999 0.37 0.372 0.374 0.376 0.378 0.38 0.38200000000000001 0.38400000000000001 0.38600000000000001 0.38800000000000001 0.39000000000000001 0.39200000000000002 0.39400000000000002 0.39600000000000002 0.39800000000000002 0.40000000000000002 0.40200000000000002 0.40400000000000003 0.40600000000000003 0.40799999999999997 0.40999999999999998 0.41199999999999998 0.41399999999999998 0.41599999999999998 0.41799999999999998 0.41999999999999998 0.42199999999999999 0.42399999999999999 0.42599999999999999 0.42799999999999999 0.42999999999999999 0.432 0.434 0.436 0.438 0.44 0.442 0.44400000000000001 0.44600000000000001 0.44800000000000001 0.45000000000000001 0.45200000000000001 0.45400000000000001 0.45600000000000002 0.45800000000000002 0.46000000000000002 0.46200000000000002 0.46400000000000002 0.46600000000000003 0.46800000000000003 0.46999999999999997 0.47199999999999998 0.47399999999999998 0.47599999999999998 0.47799999999999998 0.47999999999999998 0.48199999999999998 0.48399999999999999 0.48599999999999999 0.48799999999999999 0.48999999999999999 0.49199999999999999 0.49399999999999999 0.496 0.498 0.5 0.502 0.504 0.50600000000000001 0.50800000000000001 0.51000000000000001 0.51200000000000001 0.51400000000000001 0.51600000000000001 0.51800000000000002 0.52000000000000002 0.52200000000000002 0.52400000000000002 0.52600000000000002 0.52800000000000002 0.53000000000000003 0.53200000000000003 0.53400000000000003 0.53600000000000003 0.53800000000000003 0.54000000000000004 0.54200000000000004 0.54400000000000004 0.54600000000000004 0.54800000000000004 0.55000000000000004 0.55200000000000005 0.55400000000000005 0.55600000000000005 0.55800000000000005 0.56000000000000005 0.56200000000000006 0.56399999999999995 0.56599999999999995 0.56799999999999995 0.56999999999999995 0.57199999999999995 0.57399999999999995 0.57599999999999996 0.57799999999999996 0.57999999999999996 0.58199999999999996 0.58399999999999996 0.58599999999999997 0.58799999999999997 0.58999999999999997 0.59199999999999997 0.59399999999999997 0.59599999999999997 0.59799999999999998 0.59999999999999998 0.60199999999999998 0.60399999999999998 0.60599999999999998 0.60799999999999998 0.60999999999999999 0.61199999999999999 0.61399999999999999 0.61599999999999999 0.61799999999999999 0.62 0.622 0.624 0.626 0.628 0.63 0.63200000000000001 0.63400000000000001 0.63600000000000001 0.63800000000000001 0.64000000000000001 0.64200000000000002 0.64400000000000002 0.64600000000000002 0.64800000000000002 0.65000000000000002 0.65200000000000002 0.65400000000000003 0.65600000000000003 0.65800000000000003 0.66000000000000003 0.66200000000000003 0.66400000000000003 0.66600000000000004 0.66800000000000004 0.67000000000000004 0.67200000000000004 0.67400000000000004 0.67600000000000005 0.67800000000000005 0.68000000000000005 0.68200000000000005 0.68400000000000005 0.68600000000000005 0.68799999999999994 0.68999999999999995 0.69199999999999995 0.69399999999999995 0.69599999999999995 0.69799999999999995 0.69999999999999996 0.70199999999999996 0.70399999999999996 0.70599999999999996 0.70799999999999996 0.70999999999999996 0.71199999999999997 0.71399999999999997 0.71599999999999997 0.71799999999999997 0.71999999999999997 0.72199999999999998 0.72399999999999998 0.72599999999999998 0.72799999999999998 0.72999999999999998 0.73199999999999998 0.73399999999999999 0.73599999999999999 0.73799999999999999 0.73999999999999999 0.74199999999999999 0.74399999999999999 0.746 0.748 0.74999899999999997 0.74999901999999996 0.74999903999999995 0.74999906000000005 0.74999908000000004 0.74999910000000003 0.74999912000000002 0.74999914000000001 0.74999916 0.74999917999999999 0.74999919999999998 0.74999921999999997 0.74999923999999996 0.74999925999999995 0.74999928000000005 0.74999930000000004 0.74999932000000002 0.74999934000000001 0.74999936 0.74999937999999999 0.74999939999999998 0.74999941999999997 0.74999943999999996 0.74999945999999995 0.74999948000000005 0.74999950000000004 0.74999952000000003 0.74999954000000002 0.74999956000000001 0.74999958 0.74999959999999999 0.74999961999999998 0.74999963999999997 0.74999965999999996 0.74999967999999995 0.74999970000000005 0.74999972000000004 0.74999974000000003 0.74999976000000002 0.74999978 0.74999979999999999 0.74999981999999998 0.74999983999999997 0.74999985999999996 0.74999987999999995 0.74999990000000005 0.74999992000000004 0.74999994000000003 0.74999996000000002 0.74999998000000001 0.75 0.75000001999999999 0.75000003999999998 0.75000005999999997 0.75000007999999996 0.75000009999999995 0.75000012000000005 0.75000014000000004 0.75000016000000003 0.75000018000000002 0.75000020000000001 0.75000022 0.75000023999999998 0.75000025999999997 0.75000027999999996 0.75000029999999995 0.75000032000000005 0.75000034000000004 0.75000036000000003 0.75000038000000002 0.75000040000000001 0.75000042 0.75000043999999999 0.75000045999999998 0.75000047999999997 0.75000049999999996 0.75000051999999995 0.75000054000000005 0.75000056000000004 0.75000058000000003 0.75000060000000002 0.75000062000000001 0.75000064 0.75000065999999999 0.75000067999999998 0.75000069999999996 0.75000071999999995 0.75000074000000005 0.75000076000000004 0.75000078000000003 0.75000080000000002 0.75000082000000001 0.75000084 0.75000085999999999 0.75000087999999998 0.75000089999999997 0.75000091999999996 0.75000093999999995 0.75000096000000005 0.75000098000000004 0.75000100000000003 0.752 0.754 0.75600000000000001 0.75800000000000001 0.76000000000000001 0.76200000000000001 0.76400000000000001 0.76600000000000001 0.76800000000000002 0.77000000000000002 0.77200000000000002 0.77400000000000002 0.77600000000000002 0.77800000000000002 0.78000000000000003 0.78200000000000003 0.78400000000000003 0.78600000000000003 0.78800000000000003 0.79000000000000004 0.79200000000000004 0.79400000000000004 0.79600000000000004 0.79800000000000004 0.80000000000000004 0.80200000000000005 0.80400000000000005 0.80600000000000005 0.80800000000000005 0.81000000000000005 0.81200000000000006 0.81399999999999995 0.81599999999999995 0.81799999999999995 0.81999999999999995 0.82199999999999995 0.82399999999999995 0.82599999999999996 0.82799999999999996 0.82999999999999996 0.83199999999999996 0.83399999999999996 0.83599999999999997 0.83799999999999997 0.83999999999999997 0.84199999999999997 0.84399999999999997 0.84599999999999997 0.84799999999999998 0.84999999999999998 0.85199999999999998 0.85399999999999998 0.85599999999999998 0.85799999999999998 0.85999999999999999 0.86199999999999999 0.86399999999999999 0.86599999999999999 0.86799999999999999 0.87 0.872 0.874 0.876 0.878 0.88 0.88200000000000001 0.88400000000000001 0.88600000000000001 0.88800000000000001 0.89000000000000001 0.89200000000000002 0.89400000000000002 0.89600000000000002 0.89800000000000002 0.90000000000000002 0.90200000000000002 0.90400000000000003 0.90600000000000003 0.90800000000000003 0.91000000000000003 0.91200000000000003 0.91400000000000003 0.91600000000000004 0.91800000000000004 0.92000000000000004 0.92200000000000004 0.92400000000000004 0.92600000000000005 0.92800000000000005 0.93000000000000005 0.93200000000000005 0.93400000000000005 0.93600000000000005 0.93799999999999994 0.93999999999999995 0.94199999999999995 0.94399999999999995 0.94599999999999995 0.94799999999999995 0.94999999999999996 0.95199999999999996 0.95399999999999996 0.95599999999999996 0.95799999999999996 0.95999999999999996 0.96199999999999997 0.96399999999999997 0.96599999999999997 0.96799999999999997 0.96999999999999997 0.97199999999999998 0.97399999999999998 0.97599999999999998 0.97799999999999998 0.97999999999999998 0.98199999999999998 0.98399999999999999 0.98599999999999999 0.98799999999999999 0.98999999999999999 0.99199999999999999 0.99399999999999999 0.996 0.998 1 1.002 1.004 1.006 1.008 1.01 1.012 1.014 1.016 1.018 1.02 1.022 1.024 1.026 1.028 1.03 1.032 1.034 1.036 1.038 1.04 1.042 1.044 1.046 1.048 1.05 1.052 1.054 1.056 1.0580000000000001 1.0600000000000001 1.0620000000000001 1.0640000000000001 1.0660000000000001 1.0680000000000001 1.0700000000000001 1.0720000000000001 1.0740000000000001 1.0760000000000001 1.0780000000000001 1.0800000000000001 1.0820000000000001 1.0840000000000001 1.0860000000000001 1.0880000000000001 1.0900000000000001 1.0920000000000001 1.0940000000000001 1.0960000000000001 1.0980000000000001 1.1000000000000001 1.1020000000000001 1.1040000000000001 1.1060000000000001 1.1080000000000001 1.1100000000000001 1.1120000000000001 1.1140000000000001 1.1160000000000001 1.1180000000000001 1.1200000000000001 1.1220000000000001 1.1240000000000001 1.1259999999999999 1.1279999999999999 1.1299999999999999 1.1319999999999999 1.1339999999999999 1.1359999999999999 1.1379999999999999 1.1399999999999999 1.1419999999999999 1.1439999999999999 1.1459999999999999 1.1479999999999999 1.1499999999999999 1.1519999999999999 1.1539999999999999 1.1559999999999999 1.1579999999999999 1.1599999999999999 1.1619999999999999 1.1639999999999999 1.1659999999999999 1.1679999999999999 1.1699999999999999 1.1719999999999999 1.1739999999999999 1.1759999999999999 1.1779999999999999 1.1799999999999999 1.1819999999999999 1.1839999999999999 1.1859999999999999 1.1879999999999999 1.1899999999999999 1.1919999999999999 1.194 1.196 1.198 1.2 1.202 1.204 1.206 1.208 1.21 1.212 1.214 1.216 1.218 1.22 1.222 1.224 1.226 1.228 1.23 1.232 1.234 1.236 1.238 1.24 1.242 1.244 1.246 1.248 1.25 1.252 1.254 1.256 1.258 1.26 1.262 1.264 1.266 1.268 1.27 1.272 1.274 1.276 1.278 1.28 1.282 1.284 1.286 1.288 1.29 1.292 1.294 1.296 1.298 1.3 1.302 1.304 1.306 1.3080000000000001 1.3100000000000001 1.3120000000000001 1.3140000000000001 1.3160000000000001 1.3180000000000001 1.3200000000000001 1.3220000000000001 1.3240000000000001 1.3260000000000001 1.3280000000000001 1.3300000000000001 1.3320000000000001 1.3340000000000001 1.3360000000000001 1.3380000000000001 1.3400000000000001 1.3420000000000001 1.3440000000000001 1.3460000000000001 1.3480000000000001 1.3500000000000001 1.3520000000000001 1.3540000000000001 1.3560000000000001 1.3580000000000001 1.3600000000000001 1.3620000000000001 1.3640000000000001 1.3660000000000001 1.3680000000000001 1.3700000000000001 1.3720000000000001 1.3740000000000001 1.3759999999999999 1.3779999999999999 1.3799999999999999 1.3819999999999999 1.3839999999999999 1.3859999999999999 1.3879999999999999 1.3899999999999999 1.3919999999999999 1.3939999999999999 1.3959999999999999 1.3979999999999999 1.3999999999999999 1.4019999999999999 1.4039999999999999 1.4059999999999999 1.4079999999999999 1.4099999999999999 1.4119999999999999 1.4139999999999999 1.4159999999999999 1.4179999999999999 1.4199999999999999 1.4219999999999999 1.4239999999999999 1.4259999999999999 1.4279999999999999 1.4299999999999999 1.4319999999999999 1.4339999999999999 1.4359999999999999 1.4379999999999999 1.4399999999999999 1.4419999999999999 1.444 1.446 1.448 1.45 1.452 1.454 1.456 1.458 1.46 1.462 1.464 1.466 1.468 1.47 1.472 1.474 1.476 1.478 1.48 1.482 1.484 1.486 1.488 1.49 1.492 1.494 1.496 1.498 1.5 1.502 1.504 1.506 1.508 1.51 1.512 1.514 1.516 1.518 1.52 1.522 1.524 1.526 1.528 1.53 1.532 1.534 1.536 1.538 1.54 1.542 1.544 1.546 1.548 1.55 1.552 1.554 1.556 1.5580000000000001 1.5600000000000001 1.5620000000000001 1.5640000000000001 1.5660000000000001 1.5680000000000001 1.5700000000000001 1.5720000000000001 1.5740000000000001 1.5760000000000001 1.5780000000000001 1.5800000000000001 1.5820000000000001 1.5840000000000001 1.5860000000000001 1.5880000000000001 1.5900000000000001 1.5920000000000001 1.5940000000000001 1.5960000000000001 1.5980000000000001 1.6000000000000001 1.6020000000000001 1.6040000000000001 1.6060000000000001 1.6080000000000001 1.6100000000000001 1.6120000000000001 1.6140000000000001 1.6160000000000001 1.6180000000000001 1.6200000000000001 1.6220000000000001 1.6240000000000001 1.6259999999999999 1.6279999999999999 1.6299999999999999 1.6319999999999999 1.6339999999999999 1.6359999999999999 1.6379999999999999 1.6399999999999999 1.6419999999999999 1.6439999999999999 1.6459999999999999 1.6479999999999999 1.6499999999999999 1.6519999999999999 1.6539999999999999 1.6559999999999999 1.6579999999999999 1.6599999999999999 1.6619999999999999 1.6639999999999999 1.6659999999999999 1.6679999999999999 1.6699999999999999 1.6719999999999999 1.6739999999999999 1.6759999999999999 1.6779999999999999 1.6799999999999999 1.6819999999999999 1.6839999999999999 1.6859999999999999 1.6879999999999999 1.6899999999999999 1.6919999999999999 1.694 1.696 1.698 1.7 1.702 1.704 1.706 1.708 1.71 1.712 1.714 1.716 1.718 1.72 1.722 1.724 1.726 1.728 1.73 1.732 1.734 1.736 1.738 1.74 1.742 1.744 1.746 1.748 1.75 1.752 1.754 1.756 1.758 1.76 1.762 1.764 1.766 1.768 1.77 1.772 1.774 1.776 1.778 1.78 1.782 1.784 1.786 1.788 1.79 1.792 1.794 1.796 1.798 1.8 1.802 1.804 1.806 1.8080000000000001 1.8100000000000001 1.8120000000000001 1.8140000000000001 1.8160000000000001 1.8180000000000001 1.8200000000000001 1.8220000000000001 1.8240000000000001 1.8260000000000001 1.8280000000000001 1.8300000000000001 1.8320000000000001 1.8340000000000001 1.8360000000000001 1.8380000000000001 1.8400000000000001 1.8420000000000001 1.8440000000000001 1.8460000000000001 1.8480000000000001 1.8500000000000001 1.8520000000000001 1.8540000000000001 1.8560000000000001 1.8580000000000001 1.8600000000000001 1.8620000000000001 1.8640000000000001 1.8660000000000001 1.8680000000000001 1.8700000000000001 1.8720000000000001 1.8740000000000001 1.8759999999999999 1.8779999999999999 1.8799999999999999 1.8819999999999999 1.8839999999999999 1.8859999999999999 1.8879999999999999 1.8899999999999999 1.8919999999999999 1.8939999999999999 1.8959999999999999 1.8979999999999999 1.8999999999999999 1.9019999999999999 1.9039999999999999 1.9059999999999999 1.9079999999999999 1.9099999999999999 1.9119999999999999 1.9139999999999999 1.9159999999999999 1.9179999999999999 1.9199999999999999 1.9219999999999999 1.9239999999999999 1.9259999999999999 1.9279999999999999 1.9299999999999999 1.9319999999999999 1.9339999999999999 1.9359999999999999 1.9379999999999999 1.9399999999999999 1.9419999999999999 1.944 1.946 1.948 1.95 1.952 1.954 1.956 1.958 1.96 1.962 1.964 1.966 1.968 1.97 1.972 1.974 1.976 1.978 1.98 1.982 1.984 1.986 1.988 1.99 1.992 1.994 1.996 1.998 2] strobeoutput=all
save u count z history edit sample
