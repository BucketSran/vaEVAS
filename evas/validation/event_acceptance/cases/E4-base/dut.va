`include "disciplines.vams"
module m(u,count,z,history,edit,sample,r);
input u; output count,z,history,edit,sample; inout r;
electrical u,count,z,history,edit,sample,r;
real q; integer n,k;
analog begin
@(initial_step) begin q=0.125; n=0; k=0; end
@(timer(0.25,0,1e-12)) begin q=0.28125; k=k+1; end
V(z,r)<+idt(V(u,r),0);
@(cross(V(z,r)-q,1,1e-9,1e-8)) n=n+1;
V(history,r)<+0; V(sample,r)<+0;
V(count,r)<+n; V(edit,r)<+k;
end
endmodule
