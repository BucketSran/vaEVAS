`include "disciplines.vams"
module m(u,count,z,history,edit,sample,r);
input u; output count,z,history,edit,sample; inout r;
electrical u,count,z,history,edit,sample,r;
real next; integer q,n,k;
analog begin
@(initial_step) begin next=0.75; q=1; n=0; k=0; end
@(timer(0.25,0,1e-12)) begin next=0.5; k=k+1; end
@(timer(next,0,1e-12)) begin q=-1; n=n+1; end
V(z,r)<+idt(q*pow(V(z,r),2),1);
V(history,r)<+0; V(sample,r)<+0;
V(count,r)<+n; V(edit,r)<+k;
end
endmodule
