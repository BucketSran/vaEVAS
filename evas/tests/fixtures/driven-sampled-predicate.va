`include "disciplines.vams"
module sampled_predicate(u,y,z);
input u; output y,z; electrical u,y,z;
real q;
analog begin
 @(initial_step)q=0;
 @(timer(0.25))q=V(u)+0.25;
 V(y)<+((q-V(u)>0.125)?1:0);
 V(z)<+transition(q,0,0.125,0.125);
end
endmodule
