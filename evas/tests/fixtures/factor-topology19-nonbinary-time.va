`include "disciplines.vams"
module m(u0,u1,u2,u3,u4,u5,u6,u7,u8,u9,u10,u11,u12,u13,u14,y,supply,reference); input u0,u1,u2,u3,u4,u5,u6,u7,u8,u9,u10,u11,u12,u13,u14,supply,reference; output y; electrical u0,u1,u2,u3,u4,u5,u6,u7,u8,u9,u10,u11,u12,u13,u14,y,supply,reference; analog begin V(y)<+slew(V(reference)+0.0625*((V(supply)+V(0,reference))*((V(u0)>0.5?1.0:0.0)+(V(u1)>0.5?1.0:0.0)+(V(u2)>0.5?1.0:0.0)+(V(u3)>0.5?1.0:0.0)+(V(u4)>0.5?1.0:0.0)+(V(u5)>0.5?1.0:0.0)+(V(u6)>0.5?1.0:0.0)+(V(u7)>0.5?1.0:0.0)+(V(u8)>0.5?1.0:0.0)+(V(u9)>0.5?1.0:0.0)+(V(u10)>0.5?1.0:0.0)+(V(u11)>0.5?1.0:0.0)+(V(u12)>0.5?1.0:0.0)+(V(u13)>0.5?1.0:0.0)+(V(u14)>0.5?1.0:0.0)))+V(0,reference),20000000.0,-20000000.0); end endmodule
