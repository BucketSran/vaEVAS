`include "disciplines.vams"
module m(u,y,r); input u; output y; inout r; electrical u,y,r; real s,q; electrical z; analog begin @(initial_step) begin s=0; q=0; end
@(timer(0.25,0,1e-12)) s=1;
@(timer(0.375,0,1e-12)) begin if(V(z,r)>=1.5) q=2; else q=3; end
V(z,r)<+1+transition(s,0,0.25,0.25); V(y,r)<+q; end endmodule
