`include "disciplines.vams"
module private_phase(y); output y; electrical y; real p;
analog begin p=2*idt(1,0); V(y)<+p; end endmodule
